** sch_path: /home/agrancagnolo/Prueba_PI_Lore/SoC_for_CubeSat/xschem/adc_top_tb.sch
**.subckt adc_top_tb
x1 result0 result1 result2 result3 result4 result5 result6 result7 result8 result9 result10 result11 result12 result13 result14
+ result15 VDD GND conv_finished rst_n start_conv clk_vcm inp inn avg_mode0 avg_mode1 avg_mode2 osr_mode0 osr_mode1 osr_mode2 row_mode
+ col_mode nc0 nc1 dlyctrl4_0 dlyctrl4_1 dlyctrl4_2 dlyctrl4_3 dlyctrl4_4 dlyctrl4_5 dlyctrl1_0 dlyctrl1_1 dlyctrl1_2 dlyctrl1_3 dlyctrl1_4
+ dlyctrl2_0 dlyctrl2_1 dlyctrl2_2 dlyctrl2_3 dlyctrl2_4 dlyctrl3_0 dlyctrl3_1 dlyctrl3_2 dlyctrl3_3 dlyctrl3_4 en_dly_contr conv_finished_osr
+ adc_top
V_VDD_1 VDD GND 1.8
V_VCM_2 vcm GND 0.9
* noconn result[0..15]
* noconn conv_finished
V_VCM_1 inp vcm {vdiff/2}
V_VCM_3 vcm inn {vdiff/2}
V_VCM clk_vcm GND 0 pulse(0 1.8 {0.5/fclk} 1n 1n {0.5/fclk} {1/fclk})
V1 rst_n GND 0 pulse(0 1.8 {treset} 1n 1n 1 2)
V31 start_conv GND 0 pulse(0 1.8 {tstartconv} 1n 1n 400n 1.4u)
V4 dlyctrl1_4 GND {bit4}
V5 dlyctrl1_3 GND {bit3}
V6 dlyctrl1_2 GND {bit2}
V7 dlyctrl1_1 GND {bit1}
V8 dlyctrl1_0 GND {bit0}
V2 avg_mode2 GND {avg2}
V3 avg_mode1 GND {avg1}
V25 avg_mode0 GND {avg0}
V19 dlyctrl4_5 GND {ed_bit5}
V20 dlyctrl4_4 GND {ed_bit4}
V21 dlyctrl4_3 GND {ed_bit3}
V22 dlyctrl4_2 GND {ed_bit2}
V23 dlyctrl4_1 GND {ed_bit1}
V24 dlyctrl4_0 GND {ed_bit0}
V26 en_dly_contr GND {dlyctrl}
V27 osr_mode2 GND {osr2}
V28 osr_mode1 GND {osr1}
V29 osr_mode0 GND {osr0}
V30 nc0 GND 0
V9 dlyctrl2_4 GND {bit4}
V10 dlyctrl2_3 GND {bit3}
V11 dlyctrl2_2 GND {bit2}
V12 dlyctrl2_1 GND {bit1}
V13 dlyctrl2_0 GND {bit0}
V14 dlyctrl3_4 GND {bit4}
V15 dlyctrl3_3 GND {bit3}
V16 dlyctrl3_2 GND {bit2}
V17 dlyctrl3_1 GND {bit1}
V18 dlyctrl3_0 GND {bit0}
* noconn conv_finished_osr
V40 col_mode GND {colmode}
V41 row_mode GND {rowmode}
**** begin user architecture code

** opencircuitdesign pdks install
.lib ../dependencies/pdks/sky130A/libs.tech/ngspice/sky130.lib.spice tt

* xyce commands

*.include /foss/designs/SKY130_SAR-ADC1/spice/adc_core_digital.spice
*.include /foss/designs/SKY130_SAR-ADC1/spice/adc_core_digital.v.xspice
.include adc_core_digital.v.xspice
.include adc_clkgen_with_edgedetect.gds.lvs.spice
*.include /foss/designs/SKY130_SAR-ADC1/spice/adc_clkgen_with_edgedetect.gds.lvs.spice
*.include /foss/designs/SKY130_SAR-ADC1/xspice/adc_clkgen_with_edgedetect.xspice

* mind the order: include AFTER XSPICE FILES
*.include /foss/pdks/sky130A/libs.ref/sky130_fd_sc_hd/spice/sky130_fd_sc_hd.spice

****************
* Misc
****************
.param fclk=32768
.param treset=150n
.param tstartconv=500n
.param vdiff=200m

****************
* Delay Config
****************
.param dlyctrl = 1.8

* delay 1-3
.param bit0 = 0
.param bit1 = 1.8
.param bit2 = 0
.param bit3 = 0
.param bit4 = 0

* edgedetect pulse
.param ed_bit0 = 0
.param ed_bit1 = 0
.param ed_bit2 = 1.8
.param ed_bit3 = 1.8
.param ed_bit4 = 0
.param ed_bit5 = 0

****************
* Averaging Config
****************
.param avg0 = 0
.param avg1 = 0
.param avg2 = 0

****************
* OSR Config
****************
.param osr0 = 0
.param osr1 = 0
.param osr2 = 0

.OPTIONS TIMEINT BREAKPOINTS=610us,611us,612us
.tran 1n 3.2u

.print tran format=raw file=adc_top_tb.raw  v(xrst_n) v(start_conv) v(clk_vcm) v(result*) v(conv_finished) v(conv_finished_osr) {((v(result0)*0.0625+v(result1)*0.125+v(result2)*0.25+v(result3)*0.5+v(result4)+v(result5)*2+v(result6)*4+v(result7)*8+v(result8)*16+v(result9)*32+v(result10)*64+v(result11)*128+v(result12)*256+v(result13)*512+v(result14)*1024+v(result15)*2048)-2048*1.8)/2048}

**** end user architecture code
**.ends

* expanding   symbol:  adc_top.sym # of pins=12
** sym_path: /home/agrancagnolo/Prueba_PI_Lore/SoC_for_CubeSat/xschem/adc_top.sym
** sch_path: /home/agrancagnolo/Prueba_PI_Lore/SoC_for_CubeSat/xschem/adc_top.sch
.subckt adc_top result0 result1 result2 result3 result4 result5 result6 result7 result8 result9 result10 result11 result12
+ result13 result14 result15 VDD VSS conv_finished rst_n start_conv clk_vcm inp inn config1_0 config1_1 config1_2 config1_3 config1_4
+ config1_5 config1_6 config1_7 config1_8 config1_9 config1_10 config1_11 config1_12 config1_13 config1_14 config1_15 config2_0 config2_1
+ config2_2 config2_3 config2_4 config2_5 config2_6 config2_7 config2_8 config2_9 config2_10 config2_11 config2_12 config2_13 config2_14
+ config2_15 conv_finished_osr
*.iopin VDD
*.iopin VSS
*.ipin rst_n
*.ipin start_conv
*.ipin clk_vcm
*.ipin inp
*.ipin inn
*.ipin
*+ config1_0,config1_1,config1_2,config1_3,config1_4,config1_5,config1_6,config1_7,config1_8,config1_9,config1_10,config1_11,config1_12,config1_13,config1_14,config1_15
*.ipin
*+ config2_0,config2_1,config2_2,config2_3,config2_4,config2_5,config2_6,config2_7,config2_8,config2_9,config2_10,config2_11,config2_12,config2_13,config2_14,config2_15
*.opin
*+ result0,result1,result2,result3,result4,result5,result6,result7,result8,result9,result10,result11,result12,result13,result14,result15
*.opin conv_finished
*.opin conv_finished_osr
x1 VDD VSS clk_dig comparator_result config1_0 config1_1 config1_2 config1_3 config1_4 config1_5 config1_6 config1_7 config1_8
+ config1_9 config1_10 config1_11 config1_12 config1_13 config1_14 config1_15 config2_0 config2_1 config2_2 config2_3 config2_4 config2_5
+ config2_6 config2_7 config2_8 config2_9 config2_10 config2_11 config2_12 config2_13 config2_14 config2_15 conv_finished ena
+ nmatrix_bincap_n_0 nmatrix_bincap_n_1 nmatrix_bincap_n_2 nmatrix_c0_n nmatrix_col_n_0 nmatrix_col_n_1 nmatrix_col_n_2 nmatrix_col_n_3
+ nmatrix_col_n_4 nmatrix_col_n_5 nmatrix_col_n_6 nmatrix_col_n_7 nmatrix_col_n_8 nmatrix_col_n_9 nmatrix_col_n_10 nmatrix_col_n_11
+ nmatrix_col_n_12 nmatrix_col_n_13 nmatrix_col_n_14 nmatrix_col_n_15 nmatrix_col_n_16 nmatrix_col_n_17 nmatrix_col_n_18 nmatrix_col_n_19
+ nmatrix_col_n_20 nmatrix_col_n_21 nmatrix_col_n_22 nmatrix_col_n_23 nmatrix_col_n_24 nmatrix_col_n_25 nmatrix_col_n_26 nmatrix_col_n_27
+ nmatrix_col_n_28 nmatrix_col_n_29 nmatrix_col_n_30 nmatrix_col_n_31 nmatrix_row_n_0 nmatrix_row_n_1 nmatrix_row_n_2 nmatrix_row_n_3
+ nmatrix_row_n_4 nmatrix_row_n_5 nmatrix_row_n_6 nmatrix_row_n_7 nmatrix_row_n_8 nmatrix_row_n_9 nmatrix_row_n_10 nmatrix_row_n_11
+ nmatrix_row_n_12 nmatrix_row_n_13 nmatrix_row_n_14 nmatrix_row_n_15 nmatrix_rowon_n_0 nmatrix_rowon_n_1 nmatrix_rowon_n_2 nmatrix_rowon_n_3
+ nmatrix_rowon_n_4 nmatrix_rowon_n_5 nmatrix_rowon_n_6 nmatrix_rowon_n_7 nmatrix_rowon_n_8 nmatrix_rowon_n_9 nmatrix_rowon_n_10 nmatrix_rowon_n_11
+ nmatrix_rowon_n_12 nmatrix_rowon_n_13 nmatrix_rowon_n_14 nmatrix_rowon_n_15 pmatrix_bincap_n_0 pmatrix_bincap_n_1 pmatrix_bincap_n_2 pmatrix_c0_n
+ pmatrix_col_n_0 pmatrix_col_n_1 pmatrix_col_n_2 pmatrix_col_n_3 pmatrix_col_n_4 pmatrix_col_n_5 pmatrix_col_n_6 pmatrix_col_n_7 pmatrix_col_n_8
+ pmatrix_col_n_9 pmatrix_col_n_10 pmatrix_col_n_11 pmatrix_col_n_12 pmatrix_col_n_13 pmatrix_col_n_14 pmatrix_col_n_15 pmatrix_col_n_16
+ pmatrix_col_n_17 pmatrix_col_n_18 pmatrix_col_n_19 pmatrix_col_n_20 pmatrix_col_n_21 pmatrix_col_n_22 pmatrix_col_n_23 pmatrix_col_n_24
+ pmatrix_col_n_25 pmatrix_col_n_26 pmatrix_col_n_27 pmatrix_col_n_28 pmatrix_col_n_29 pmatrix_col_n_30 pmatrix_col_n_31 pmatrix_row_n_0
+ pmatrix_row_n_1 pmatrix_row_n_2 pmatrix_row_n_3 pmatrix_row_n_4 pmatrix_row_n_5 pmatrix_row_n_6 pmatrix_row_n_7 pmatrix_row_n_8 pmatrix_row_n_9
+ pmatrix_row_n_10 pmatrix_row_n_11 pmatrix_row_n_12 pmatrix_row_n_13 pmatrix_row_n_14 pmatrix_row_n_15 pmatrix_rowon_n_0 pmatrix_rowon_n_1
+ pmatrix_rowon_n_2 pmatrix_rowon_n_3 pmatrix_rowon_n_4 pmatrix_rowon_n_5 pmatrix_rowon_n_6 pmatrix_rowon_n_7 pmatrix_rowon_n_8 pmatrix_rowon_n_9
+ pmatrix_rowon_n_10 pmatrix_rowon_n_11 pmatrix_rowon_n_12 pmatrix_rowon_n_13 pmatrix_rowon_n_14 pmatrix_rowon_n_15 result0 result1 result2 result3
+ result4 result5 result6 result7 result8 result9 result10 result11 result12 result13 result14 result15 rst_n sample_matrix sample_matrix_n
+ sample_switch sample_switch_n nmatrix_rowoff_n_0 nmatrix_rowoff_n_1 nmatrix_rowoff_n_2 nmatrix_rowoff_n_3 nmatrix_rowoff_n_4 nmatrix_rowoff_n_5
+ nmatrix_rowoff_n_6 nmatrix_rowoff_n_7 nmatrix_rowoff_n_8 nmatrix_rowoff_n_9 nmatrix_rowoff_n_10 nmatrix_rowoff_n_11 nmatrix_rowoff_n_12
+ nmatrix_rowoff_n_13 nmatrix_rowoff_n_14 nmatrix_rowoff_n_15 nmatrix_col_0 nmatrix_col_1 nmatrix_col_2 nmatrix_col_3 nmatrix_col_4 nmatrix_col_5
+ nmatrix_col_6 nmatrix_col_7 nmatrix_col_8 nmatrix_col_9 nmatrix_col_10 nmatrix_col_11 nmatrix_col_12 nmatrix_col_13 nmatrix_col_14
+ nmatrix_col_15 nmatrix_col_16 nmatrix_col_17 nmatrix_col_18 nmatrix_col_19 nmatrix_col_20 nmatrix_col_21 nmatrix_col_22 nmatrix_col_23
+ nmatrix_col_24 nmatrix_col_25 nmatrix_col_26 nmatrix_col_27 nmatrix_col_28 nmatrix_col_29 nmatrix_col_30 nmatrix_col_31 pmatrix_rowoff_n_0
+ pmatrix_rowoff_n_1 pmatrix_rowoff_n_2 pmatrix_rowoff_n_3 pmatrix_rowoff_n_4 pmatrix_rowoff_n_5 pmatrix_rowoff_n_6 pmatrix_rowoff_n_7
+ pmatrix_rowoff_n_8 pmatrix_rowoff_n_9 pmatrix_rowoff_n_10 pmatrix_rowoff_n_11 pmatrix_rowoff_n_12 pmatrix_rowoff_n_13 pmatrix_rowoff_n_14
+ pmatrix_rowoff_n_15 pmatrix_col_0 pmatrix_col_1 pmatrix_col_2 pmatrix_col_3 pmatrix_col_4 pmatrix_col_5 pmatrix_col_6 pmatrix_col_7 pmatrix_col_8
+ pmatrix_col_9 pmatrix_col_10 pmatrix_col_11 pmatrix_col_12 pmatrix_col_13 pmatrix_col_14 pmatrix_col_15 pmatrix_col_16 pmatrix_col_17
+ pmatrix_col_18 pmatrix_col_19 pmatrix_col_20 pmatrix_col_21 pmatrix_col_22 pmatrix_col_23 pmatrix_col_24 pmatrix_col_25 pmatrix_col_26
+ pmatrix_col_27 pmatrix_col_28 pmatrix_col_29 pmatrix_col_30 pmatrix_col_31 conv_finished_osr adc_core_digital
x2 VDD VSS vcm sample_p nsample_p pmatrix_row_n_0 pmatrix_row_n_1 pmatrix_row_n_2 pmatrix_row_n_3 pmatrix_row_n_4 pmatrix_row_n_5
+ pmatrix_row_n_6 pmatrix_row_n_7 pmatrix_row_n_8 pmatrix_row_n_9 pmatrix_row_n_10 pmatrix_row_n_11 pmatrix_row_n_12 pmatrix_row_n_13
+ pmatrix_row_n_14 pmatrix_row_n_15 pmatrix_rowon_n_0 pmatrix_rowon_n_1 pmatrix_rowon_n_2 pmatrix_rowon_n_3 pmatrix_rowon_n_4 pmatrix_rowon_n_5
+ pmatrix_rowon_n_6 pmatrix_rowon_n_7 pmatrix_rowon_n_8 pmatrix_rowon_n_9 pmatrix_rowon_n_10 pmatrix_rowon_n_11 pmatrix_rowon_n_12 pmatrix_rowon_n_13
+ pmatrix_rowon_n_14 pmatrix_rowon_n_15 pmatrix_col_n_0 pmatrix_col_n_1 pmatrix_col_n_2 pmatrix_col_n_3 pmatrix_col_n_4 pmatrix_col_n_5
+ pmatrix_col_n_6 pmatrix_col_n_7 pmatrix_col_n_8 pmatrix_col_n_9 pmatrix_col_n_10 pmatrix_col_n_11 pmatrix_col_n_12 pmatrix_col_n_13
+ pmatrix_col_n_14 pmatrix_col_n_15 pmatrix_col_n_16 pmatrix_col_n_17 pmatrix_col_n_18 pmatrix_col_n_19 pmatrix_col_n_20 pmatrix_col_n_21
+ pmatrix_col_n_22 pmatrix_col_n_23 pmatrix_col_n_24 pmatrix_col_n_25 pmatrix_col_n_26 pmatrix_col_n_27 pmatrix_col_n_28 pmatrix_col_n_29
+ pmatrix_col_n_30 pmatrix_col_n_31 pmatrix_bincap_n_0 pmatrix_bincap_n_1 pmatrix_bincap_n_2 pmatrix_c0_n sample_switch sample_switch_n inp pctop
+ pmatrix_rowoff_n_0 pmatrix_rowoff_n_1 pmatrix_rowoff_n_2 pmatrix_rowoff_n_3 pmatrix_rowoff_n_4 pmatrix_rowoff_n_5 pmatrix_rowoff_n_6
+ pmatrix_rowoff_n_7 pmatrix_rowoff_n_8 pmatrix_rowoff_n_9 pmatrix_rowoff_n_10 pmatrix_rowoff_n_11 pmatrix_rowoff_n_12 pmatrix_rowoff_n_13
+ pmatrix_rowoff_n_14 pmatrix_rowoff_n_15 pmatrix_col_0 pmatrix_col_1 pmatrix_col_2 pmatrix_col_3 pmatrix_col_4 pmatrix_col_5 pmatrix_col_6
+ pmatrix_col_7 pmatrix_col_8 pmatrix_col_9 pmatrix_col_10 pmatrix_col_11 pmatrix_col_12 pmatrix_col_13 pmatrix_col_14 pmatrix_col_15
+ pmatrix_col_16 pmatrix_col_17 pmatrix_col_18 pmatrix_col_19 pmatrix_col_20 pmatrix_col_21 pmatrix_col_22 pmatrix_col_23 pmatrix_col_24
+ pmatrix_col_25 pmatrix_col_26 pmatrix_col_27 pmatrix_col_28 pmatrix_col_29 pmatrix_col_30 pmatrix_col_31 adc_array_matrix_12bit
x4 VDD VSS clk_comp pctop nctop comp_trig net1 comparator_result adc_comp_latch
x3 VDD VSS vcm sample_n nsample_n nmatrix_row_n_0 nmatrix_row_n_1 nmatrix_row_n_2 nmatrix_row_n_3 nmatrix_row_n_4 nmatrix_row_n_5
+ nmatrix_row_n_6 nmatrix_row_n_7 nmatrix_row_n_8 nmatrix_row_n_9 nmatrix_row_n_10 nmatrix_row_n_11 nmatrix_row_n_12 nmatrix_row_n_13
+ nmatrix_row_n_14 nmatrix_row_n_15 nmatrix_rowon_n_0 nmatrix_rowon_n_1 nmatrix_rowon_n_2 nmatrix_rowon_n_3 nmatrix_rowon_n_4 nmatrix_rowon_n_5
+ nmatrix_rowon_n_6 nmatrix_rowon_n_7 nmatrix_rowon_n_8 nmatrix_rowon_n_9 nmatrix_rowon_n_10 nmatrix_rowon_n_11 nmatrix_rowon_n_12 nmatrix_rowon_n_13
+ nmatrix_rowon_n_14 nmatrix_rowon_n_15 nmatrix_col_n_0 nmatrix_col_n_1 nmatrix_col_n_2 nmatrix_col_n_3 nmatrix_col_n_4 nmatrix_col_n_5
+ nmatrix_col_n_6 nmatrix_col_n_7 nmatrix_col_n_8 nmatrix_col_n_9 nmatrix_col_n_10 nmatrix_col_n_11 nmatrix_col_n_12 nmatrix_col_n_13
+ nmatrix_col_n_14 nmatrix_col_n_15 nmatrix_col_n_16 nmatrix_col_n_17 nmatrix_col_n_18 nmatrix_col_n_19 nmatrix_col_n_20 nmatrix_col_n_21
+ nmatrix_col_n_22 nmatrix_col_n_23 nmatrix_col_n_24 nmatrix_col_n_25 nmatrix_col_n_26 nmatrix_col_n_27 nmatrix_col_n_28 nmatrix_col_n_29
+ nmatrix_col_n_30 nmatrix_col_n_31 nmatrix_bincap_n_0 nmatrix_bincap_n_1 nmatrix_bincap_n_2 nmatrix_c0_n sample_switch sample_switch_n inn nctop
+ nmatrix_rowoff_n_0 nmatrix_rowoff_n_1 nmatrix_rowoff_n_2 nmatrix_rowoff_n_3 nmatrix_rowoff_n_4 nmatrix_rowoff_n_5 nmatrix_rowoff_n_6
+ nmatrix_rowoff_n_7 nmatrix_rowoff_n_8 nmatrix_rowoff_n_9 nmatrix_rowoff_n_10 nmatrix_rowoff_n_11 nmatrix_rowoff_n_12 nmatrix_rowoff_n_13
+ nmatrix_rowoff_n_14 nmatrix_rowoff_n_15 nmatrix_col_0 nmatrix_col_1 nmatrix_col_2 nmatrix_col_3 nmatrix_col_4 nmatrix_col_5 nmatrix_col_6
+ nmatrix_col_7 nmatrix_col_8 nmatrix_col_9 nmatrix_col_10 nmatrix_col_11 nmatrix_col_12 nmatrix_col_13 nmatrix_col_14 nmatrix_col_15
+ nmatrix_col_16 nmatrix_col_17 nmatrix_col_18 nmatrix_col_19 nmatrix_col_20 nmatrix_col_21 nmatrix_col_22 nmatrix_col_23 nmatrix_col_24
+ nmatrix_col_25 nmatrix_col_26 nmatrix_col_27 nmatrix_col_28 nmatrix_col_29 nmatrix_col_30 nmatrix_col_31 adc_array_matrix_12bit
* noconn #net1
* noconn clk_vcm
V1 vcm VSS 0.9
x6 VDD VSS clk_comp clk_dig config2_0 config2_1 config2_2 config2_3 config2_4 config2_5 config2_6 config2_7 config2_8 config2_9
+ config2_10 config2_11 config2_12 config2_13 config2_14 config1_10 config1_11 config1_12 config1_13 config1_14 config1_15 ena config2_15
+ comp_trig sample_matrix_n nsample_n sample_matrix_n nsample_p sample_matrix sample_n sample_matrix sample_p start_conv
+ adc_clkgen_with_edgedetect
.ends

* expanding   symbol:  adc_array_matrix_12bit.sym # of pins=16
** sym_path: /home/agrancagnolo/Prueba_PI_Lore/SoC_for_CubeSat/xschem/adc_array_matrix_12bit.sym
** sch_path: /home/agrancagnolo/Prueba_PI_Lore/SoC_for_CubeSat/xschem/adc_array_matrix_12bit.sch
.subckt adc_array_matrix_12bit VDD VSS vcm sample sample_n row_n[0] row_n[1] row_n[2] row_n[3] row_n[4] row_n[5] row_n[6] row_n[7]
+ row_n[8] row_n[9] row_n[10] row_n[11] row_n[12] row_n[13] row_n[14] row_n[15] rowon_n[0] rowon_n[1] rowon_n[2] rowon_n[3] rowon_n[4]
+ rowon_n[5] rowon_n[6] rowon_n[7] rowon_n[8] rowon_n[9] rowon_n[10] rowon_n[11] rowon_n[12] rowon_n[13] rowon_n[14] rowon_n[15] col_n[0]
+ col_n[1] col_n[2] col_n[3] col_n[4] col_n[5] col_n[6] col_n[7] col_n[8] col_n[9] col_n[10] col_n[11] col_n[12] col_n[13] col_n[14]
+ col_n[15] col_n[16] col_n[17] col_n[18] col_n[19] col_n[20] col_n[21] col_n[22] col_n[23] col_n[24] col_n[25] col_n[26] col_n[27] col_n[28]
+ col_n[29] col_n[30] col_n[31] en_bit_n[0] en_bit_n[1] en_bit_n[2] en_C0_n sw sw_n analog_in ctop rowoff_n[0] rowoff_n[1] rowoff_n[2]
+ rowoff_n[3] rowoff_n[4] rowoff_n[5] rowoff_n[6] rowoff_n[7] rowoff_n[8] rowoff_n[9] rowoff_n[10] rowoff_n[11] rowoff_n[12] rowoff_n[13]
+ rowoff_n[14] rowoff_n[15] col[0] col[1] col[2] col[3] col[4] col[5] col[6] col[7] col[8] col[9] col[10] col[11] col[12] col[13] col[14]
+ col[15] col[16] col[17] col[18] col[19] col[20] col[21] col[22] col[23] col[24] col[25] col[26] col[27] col[28] col[29] col[30] col[31]
*.iopin VDD
*.iopin VSS
*.iopin vcm
*.ipin sample
*.ipin sample_n
*.ipin
*+ row_n[0],row_n[1],row_n[2],row_n[3],row_n[4],row_n[5],row_n[6],row_n[7],row_n[8],row_n[9],row_n[10],row_n[11],row_n[12],row_n[13],row_n[14],row_n[15]
*.ipin
*+ rowon_n[0],rowon_n[1],rowon_n[2],rowon_n[3],rowon_n[4],rowon_n[5],rowon_n[6],rowon_n[7],rowon_n[8],rowon_n[9],rowon_n[10],rowon_n[11],rowon_n[12],rowon_n[13],rowon_n[14],rowon_n[15]
*.ipin
*+ col_n[0],col_n[1],col_n[2],col_n[3],col_n[4],col_n[5],col_n[6],col_n[7],col_n[8],col_n[9],col_n[10],col_n[11],col_n[12],col_n[13],col_n[14],col_n[15],col_n[16],col_n[17],col_n[18],col_n[19],col_n[20],col_n[21],col_n[22],col_n[23],col_n[24],col_n[25],col_n[26],col_n[27],col_n[28],col_n[29],col_n[30],col_n[31]
*.ipin en_bit_n[0],en_bit_n[1],en_bit_n[2]
*.ipin en_C0_n
*.ipin sw
*.ipin sw_n
*.ipin analog_in
*.iopin ctop
*.ipin
*+ col[0],col[1],col[2],col[3],col[4],col[5],col[6],col[7],col[8],col[9],col[10],col[11],col[12],col[13],col[14],col[15],col[16],col[17],col[18],col[19],col[20],col[21],col[22],col[23],col[24],col[25],col[26],col[27],col[28],col[29],col[30],col[31]
*.ipin
*+ rowoff_n[0],rowoff_n[1],rowoff_n[2],rowoff_n[3],rowoff_n[4],rowoff_n[5],rowoff_n[6],rowoff_n[7],rowoff_n[8],rowoff_n[9],rowoff_n[10],rowoff_n[11],rowoff_n[12],rowoff_n[13],rowoff_n[14],rowoff_n[15]
x2 VDD ctop vcm row_n[0] rowon_n[0] net2 net1 VSS col_n[1] rowoff_n[0] col[1] adc_array_wafflecap_8_8
x3 VDD ctop vcm row_n[0] rowon_n[0] net2 net1 VSS col_n[2] rowoff_n[0] col[2] adc_array_wafflecap_8_8
x4 VDD ctop vcm row_n[0] rowon_n[0] net2 net1 VSS col_n[3] rowoff_n[0] col[3] adc_array_wafflecap_8_8
x5 VDD ctop vcm row_n[0] rowon_n[0] net2 net1 VSS col_n[4] rowoff_n[0] col[4] adc_array_wafflecap_8_8
x6 VDD ctop vcm row_n[0] rowon_n[0] net2 net1 VSS col_n[5] rowoff_n[0] col[5] adc_array_wafflecap_8_8
x7 VDD ctop vcm row_n[0] rowon_n[0] net2 net1 VSS col_n[6] rowoff_n[0] col[6] adc_array_wafflecap_8_8
x8 VDD ctop vcm row_n[0] rowon_n[0] net2 net1 VSS col_n[7] rowoff_n[0] col[7] adc_array_wafflecap_8_8
x9 VDD ctop vcm row_n[0] rowon_n[0] net2 net1 VSS col_n[8] rowoff_n[0] col[8] adc_array_wafflecap_8_8
x10 VDD ctop vcm row_n[0] rowon_n[0] net2 net1 VSS col_n[9] rowoff_n[0] col[9] adc_array_wafflecap_8_8
x11 VDD ctop vcm row_n[0] rowon_n[0] net2 net1 VSS col_n[10] rowoff_n[0] col[10] adc_array_wafflecap_8_8
x12 VDD ctop vcm row_n[0] rowon_n[0] net2 net1 VSS col_n[11] rowoff_n[0] col[11] adc_array_wafflecap_8_8
x13 VDD ctop vcm row_n[0] rowon_n[0] net2 net1 VSS col_n[12] rowoff_n[0] col[12] adc_array_wafflecap_8_8
x15 VDD ctop vcm row_n[0] rowon_n[0] net2 net1 VSS col_n[14] rowoff_n[0] col[14] adc_array_wafflecap_8_8
x16 VDD ctop vcm row_n[0] rowon_n[0] net2 net1 VSS col_n[15] rowoff_n[0] col[15] adc_array_wafflecap_8_8
x17 VDD ctop vcm row_n[0] rowon_n[0] net2 net1 VSS col_n[16] rowoff_n[0] col[16] adc_array_wafflecap_8_8
x18 VDD ctop vcm row_n[0] rowon_n[0] net2 net1 VSS col_n[17] rowoff_n[0] col[17] adc_array_wafflecap_8_8
x19 VDD ctop vcm row_n[0] rowon_n[0] net2 net1 VSS col_n[18] rowoff_n[0] col[18] adc_array_wafflecap_8_8
x20 VDD ctop vcm row_n[0] rowon_n[0] net2 net1 VSS col_n[19] rowoff_n[0] col[19] adc_array_wafflecap_8_8
x21 VDD ctop vcm row_n[0] rowon_n[0] net2 net1 VSS col_n[20] rowoff_n[0] col[20] adc_array_wafflecap_8_8
x22 VDD ctop vcm row_n[0] rowon_n[0] net2 net1 VSS col_n[21] rowoff_n[0] col[21] adc_array_wafflecap_8_8
x23 VDD ctop vcm row_n[0] rowon_n[0] net2 net1 VSS col_n[22] rowoff_n[0] col[22] adc_array_wafflecap_8_8
x24 VDD ctop vcm row_n[0] rowon_n[0] net2 net1 VSS col_n[23] rowoff_n[0] col[23] adc_array_wafflecap_8_8
x25 VDD ctop vcm row_n[0] rowon_n[0] net2 net1 VSS col_n[24] rowoff_n[0] col[24] adc_array_wafflecap_8_8
x26 VDD ctop vcm row_n[0] rowon_n[0] net2 net1 VSS col_n[25] rowoff_n[0] col[25] adc_array_wafflecap_8_8
x27 VDD ctop vcm row_n[0] rowon_n[0] net2 net1 VSS col_n[26] rowoff_n[0] col[26] adc_array_wafflecap_8_8
x28 VDD ctop vcm row_n[0] rowon_n[0] net2 net1 VSS col_n[27] rowoff_n[0] col[27] adc_array_wafflecap_8_8
x29 VDD ctop vcm row_n[0] rowon_n[0] net2 net1 VSS col_n[28] rowoff_n[0] col[28] adc_array_wafflecap_8_8
x30 VDD ctop vcm row_n[0] rowon_n[0] net2 net1 VSS col_n[29] rowoff_n[0] col[29] adc_array_wafflecap_8_8
x31 VDD ctop vcm row_n[0] rowon_n[0] net2 net1 VSS col_n[30] rowoff_n[0] col[30] adc_array_wafflecap_8_8
x32 VDD ctop vcm row_n[0] rowon_n[0] net2 net1 VSS col_n[31] rowoff_n[0] col[31] adc_array_wafflecap_8_8
x33 VDD ctop vcm row_n[1] rowon_n[1] net4 net3 VSS col_n[0] rowoff_n[1] col[0] adc_array_wafflecap_8_8
x34 VDD ctop vcm row_n[1] rowon_n[1] net4 net3 VSS col_n[1] rowoff_n[1] col[1] adc_array_wafflecap_8_8
x35 VDD ctop vcm row_n[1] rowon_n[1] net4 net3 VSS col_n[2] rowoff_n[1] col[2] adc_array_wafflecap_8_8
x36 VDD ctop vcm row_n[1] rowon_n[1] net4 net3 VSS col_n[3] rowoff_n[1] col[3] adc_array_wafflecap_8_8
x37 VDD ctop vcm row_n[1] rowon_n[1] net4 net3 VSS col_n[4] rowoff_n[1] col[4] adc_array_wafflecap_8_8
x38 VDD ctop vcm row_n[1] rowon_n[1] net4 net3 VSS col_n[5] rowoff_n[1] col[5] adc_array_wafflecap_8_8
x39 VDD ctop vcm row_n[1] rowon_n[1] net4 net3 VSS col_n[6] rowoff_n[1] col[6] adc_array_wafflecap_8_8
x40 VDD ctop vcm row_n[1] rowon_n[1] net4 net3 VSS col_n[7] rowoff_n[1] col[7] adc_array_wafflecap_8_8
x41 VDD ctop vcm row_n[1] rowon_n[1] net4 net3 VSS col_n[8] rowoff_n[1] col[8] adc_array_wafflecap_8_8
x42 VDD ctop vcm row_n[1] rowon_n[1] net4 net3 VSS col_n[9] rowoff_n[1] col[9] adc_array_wafflecap_8_8
x43 VDD ctop vcm row_n[1] rowon_n[1] net4 net3 VSS col_n[10] rowoff_n[1] col[10] adc_array_wafflecap_8_8
x44 VDD ctop vcm row_n[1] rowon_n[1] net4 net3 VSS col_n[11] rowoff_n[1] col[11] adc_array_wafflecap_8_8
x45 VDD ctop vcm row_n[1] rowon_n[1] net4 net3 VSS col_n[12] rowoff_n[1] col[12] adc_array_wafflecap_8_8
x46 VDD ctop vcm row_n[1] rowon_n[1] net4 net3 VSS col_n[13] rowoff_n[1] col[13] adc_array_wafflecap_8_8
x47 VDD ctop vcm row_n[1] rowon_n[1] net4 net3 VSS col_n[14] rowoff_n[1] col[14] adc_array_wafflecap_8_8
x48 VDD ctop vcm row_n[1] rowon_n[1] net4 net3 VSS col_n[15] rowoff_n[1] col[15] adc_array_wafflecap_8_8
x49 VDD ctop vcm row_n[1] rowon_n[1] net4 net3 VSS col_n[16] rowoff_n[1] col[16] adc_array_wafflecap_8_8
x50 VDD ctop vcm row_n[1] rowon_n[1] net4 net3 VSS col_n[17] rowoff_n[1] col[17] adc_array_wafflecap_8_8
x51 VDD ctop vcm row_n[1] rowon_n[1] net4 net3 VSS col_n[18] rowoff_n[1] col[18] adc_array_wafflecap_8_8
x52 VDD ctop vcm row_n[1] rowon_n[1] net4 net3 VSS col_n[19] rowoff_n[1] col[19] adc_array_wafflecap_8_8
x53 VDD ctop vcm row_n[1] rowon_n[1] net4 net3 VSS col_n[20] rowoff_n[1] col[20] adc_array_wafflecap_8_8
x54 VDD ctop vcm row_n[1] rowon_n[1] net4 net3 VSS col_n[21] rowoff_n[1] col[21] adc_array_wafflecap_8_8
x55 VDD ctop vcm row_n[1] rowon_n[1] net4 net3 VSS col_n[22] rowoff_n[1] col[22] adc_array_wafflecap_8_8
x56 VDD ctop vcm row_n[1] rowon_n[1] net4 net3 VSS col_n[23] rowoff_n[1] col[23] adc_array_wafflecap_8_8
x57 VDD ctop vcm row_n[1] rowon_n[1] net4 net3 VSS col_n[24] rowoff_n[1] col[24] adc_array_wafflecap_8_8
x58 VDD ctop vcm row_n[1] rowon_n[1] net4 net3 VSS col_n[25] rowoff_n[1] col[25] adc_array_wafflecap_8_8
x59 VDD ctop vcm row_n[1] rowon_n[1] net4 net3 VSS col_n[26] rowoff_n[1] col[26] adc_array_wafflecap_8_8
x60 VDD ctop vcm row_n[1] rowon_n[1] net4 net3 VSS col_n[27] rowoff_n[1] col[27] adc_array_wafflecap_8_8
x61 VDD ctop vcm row_n[1] rowon_n[1] net4 net3 VSS col_n[28] rowoff_n[1] col[28] adc_array_wafflecap_8_8
x62 VDD ctop vcm row_n[1] rowon_n[1] net4 net3 VSS col_n[29] rowoff_n[1] col[29] adc_array_wafflecap_8_8
x63 VDD ctop vcm row_n[1] rowon_n[1] net4 net3 VSS col_n[30] rowoff_n[1] col[30] adc_array_wafflecap_8_8
x64 VDD ctop vcm row_n[1] rowon_n[1] net4 net3 VSS col_n[31] rowoff_n[1] col[31] adc_array_wafflecap_8_8
x65 VDD ctop vcm row_n[2] rowon_n[2] net6 net5 VSS col_n[0] rowoff_n[2] col[0] adc_array_wafflecap_8_8
x66 VDD ctop vcm row_n[2] rowon_n[2] net6 net5 VSS col_n[1] rowoff_n[2] col[1] adc_array_wafflecap_8_8
x67 VDD ctop vcm row_n[2] rowon_n[2] net6 net5 VSS col_n[2] rowoff_n[2] col[2] adc_array_wafflecap_8_8
x68 VDD ctop vcm row_n[2] rowon_n[2] net6 net5 VSS col_n[3] rowoff_n[2] col[3] adc_array_wafflecap_8_8
x69 VDD ctop vcm row_n[2] rowon_n[2] net6 net5 VSS col_n[4] rowoff_n[2] col[4] adc_array_wafflecap_8_8
x70 VDD ctop vcm row_n[2] rowon_n[2] net6 net5 VSS col_n[5] rowoff_n[2] col[5] adc_array_wafflecap_8_8
x71 VDD ctop vcm row_n[2] rowon_n[2] net6 net5 VSS col_n[6] rowoff_n[2] col[6] adc_array_wafflecap_8_8
x72 VDD ctop vcm row_n[2] rowon_n[2] net6 net5 VSS col_n[7] rowoff_n[2] col[7] adc_array_wafflecap_8_8
x73 VDD ctop vcm row_n[2] rowon_n[2] net6 net5 VSS col_n[8] rowoff_n[2] col[8] adc_array_wafflecap_8_8
x74 VDD ctop vcm row_n[2] rowon_n[2] net6 net5 VSS col_n[9] rowoff_n[2] col[9] adc_array_wafflecap_8_8
x75 VDD ctop vcm row_n[2] rowon_n[2] net6 net5 VSS col_n[10] rowoff_n[2] col[10] adc_array_wafflecap_8_8
x76 VDD ctop vcm row_n[2] rowon_n[2] net6 net5 VSS col_n[11] rowoff_n[2] col[11] adc_array_wafflecap_8_8
x77 VDD ctop vcm row_n[2] rowon_n[2] net6 net5 VSS col_n[12] rowoff_n[2] col[12] adc_array_wafflecap_8_8
x78 VDD ctop vcm row_n[2] rowon_n[2] net6 net5 VSS col_n[13] rowoff_n[2] col[13] adc_array_wafflecap_8_8
x79 VDD ctop vcm row_n[2] rowon_n[2] net6 net5 VSS col_n[14] rowoff_n[2] col[14] adc_array_wafflecap_8_8
x80 VDD ctop vcm row_n[2] rowon_n[2] net6 net5 VSS col_n[15] rowoff_n[2] col[15] adc_array_wafflecap_8_8
x81 VDD ctop vcm row_n[2] rowon_n[2] net6 net5 VSS col_n[16] rowoff_n[2] col[16] adc_array_wafflecap_8_8
x82 VDD ctop vcm row_n[2] rowon_n[2] net6 net5 VSS col_n[17] rowoff_n[2] col[17] adc_array_wafflecap_8_8
x83 VDD ctop vcm row_n[2] rowon_n[2] net6 net5 VSS col_n[18] rowoff_n[2] col[18] adc_array_wafflecap_8_8
x84 VDD ctop vcm row_n[2] rowon_n[2] net6 net5 VSS col_n[19] rowoff_n[2] col[19] adc_array_wafflecap_8_8
x85 VDD ctop vcm row_n[2] rowon_n[2] net6 net5 VSS col_n[20] rowoff_n[2] col[20] adc_array_wafflecap_8_8
x86 VDD ctop vcm row_n[2] rowon_n[2] net6 net5 VSS col_n[21] rowoff_n[2] col[21] adc_array_wafflecap_8_8
x87 VDD ctop vcm row_n[2] rowon_n[2] net6 net5 VSS col_n[22] rowoff_n[2] col[22] adc_array_wafflecap_8_8
x88 VDD ctop vcm row_n[2] rowon_n[2] net6 net5 VSS col_n[23] rowoff_n[2] col[23] adc_array_wafflecap_8_8
x89 VDD ctop vcm row_n[2] rowon_n[2] net6 net5 VSS col_n[24] rowoff_n[2] col[24] adc_array_wafflecap_8_8
x90 VDD ctop vcm row_n[2] rowon_n[2] net6 net5 VSS col_n[25] rowoff_n[2] col[25] adc_array_wafflecap_8_8
x91 VDD ctop vcm row_n[2] rowon_n[2] net6 net5 VSS col_n[26] rowoff_n[2] col[26] adc_array_wafflecap_8_8
x92 VDD ctop vcm row_n[2] rowon_n[2] net6 net5 VSS col_n[27] rowoff_n[2] col[27] adc_array_wafflecap_8_8
x93 VDD ctop vcm row_n[2] rowon_n[2] net6 net5 VSS col_n[28] rowoff_n[2] col[28] adc_array_wafflecap_8_8
x94 VDD ctop vcm row_n[2] rowon_n[2] net6 net5 VSS col_n[29] rowoff_n[2] col[29] adc_array_wafflecap_8_8
x95 VDD ctop vcm row_n[2] rowon_n[2] net6 net5 VSS col_n[30] rowoff_n[2] col[30] adc_array_wafflecap_8_8
x96 VDD ctop vcm row_n[2] rowon_n[2] net6 net5 VSS col_n[31] rowoff_n[2] col[31] adc_array_wafflecap_8_8
x97 VDD ctop vcm row_n[3] rowon_n[3] net8 net7 VSS col_n[0] rowoff_n[3] col[0] adc_array_wafflecap_8_8
x98 VDD ctop vcm row_n[3] rowon_n[3] net8 net7 VSS col_n[1] rowoff_n[3] col[1] adc_array_wafflecap_8_8
x99 VDD ctop vcm row_n[3] rowon_n[3] net8 net7 VSS col_n[2] rowoff_n[3] col[2] adc_array_wafflecap_8_8
x100 VDD ctop vcm row_n[3] rowon_n[3] net8 net7 VSS col_n[3] rowoff_n[3] col[3] adc_array_wafflecap_8_8
x101 VDD ctop vcm row_n[3] rowon_n[3] net8 net7 VSS col_n[4] rowoff_n[3] col[4] adc_array_wafflecap_8_8
x102 VDD ctop vcm row_n[3] rowon_n[3] net8 net7 VSS col_n[5] rowoff_n[3] col[5] adc_array_wafflecap_8_8
x103 VDD ctop vcm row_n[3] rowon_n[3] net8 net7 VSS col_n[6] rowoff_n[3] col[6] adc_array_wafflecap_8_8
x104 VDD ctop vcm row_n[3] rowon_n[3] net8 net7 VSS col_n[7] rowoff_n[3] col[7] adc_array_wafflecap_8_8
x105 VDD ctop vcm row_n[3] rowon_n[3] net8 net7 VSS col_n[8] rowoff_n[3] col[8] adc_array_wafflecap_8_8
x106 VDD ctop vcm row_n[3] rowon_n[3] net8 net7 VSS col_n[9] rowoff_n[3] col[9] adc_array_wafflecap_8_8
x107 VDD ctop vcm row_n[3] rowon_n[3] net8 net7 VSS col_n[10] rowoff_n[3] col[10] adc_array_wafflecap_8_8
x108 VDD ctop vcm row_n[3] rowon_n[3] net8 net7 VSS col_n[11] rowoff_n[3] col[11] adc_array_wafflecap_8_8
x109 VDD ctop vcm row_n[3] rowon_n[3] net8 net7 VSS col_n[12] rowoff_n[3] col[12] adc_array_wafflecap_8_8
x110 VDD ctop vcm row_n[3] rowon_n[3] net8 net7 VSS col_n[13] rowoff_n[3] col[13] adc_array_wafflecap_8_8
x111 VDD ctop vcm row_n[3] rowon_n[3] net8 net7 VSS col_n[14] rowoff_n[3] col[14] adc_array_wafflecap_8_8
x112 VDD ctop vcm row_n[3] rowon_n[3] net8 net7 VSS col_n[15] rowoff_n[3] col[15] adc_array_wafflecap_8_8
x113 VDD ctop vcm row_n[3] rowon_n[3] net8 net7 VSS col_n[16] rowoff_n[3] col[16] adc_array_wafflecap_8_8
x114 VDD ctop vcm row_n[3] rowon_n[3] net8 net7 VSS col_n[17] rowoff_n[3] col[17] adc_array_wafflecap_8_8
x115 VDD ctop vcm row_n[3] rowon_n[3] net8 net7 VSS col_n[18] rowoff_n[3] col[18] adc_array_wafflecap_8_8
x116 VDD ctop vcm row_n[3] rowon_n[3] net8 net7 VSS col_n[19] rowoff_n[3] col[19] adc_array_wafflecap_8_8
x117 VDD ctop vcm row_n[3] rowon_n[3] net8 net7 VSS col_n[20] rowoff_n[3] col[20] adc_array_wafflecap_8_8
x118 VDD ctop vcm row_n[3] rowon_n[3] net8 net7 VSS col_n[21] rowoff_n[3] col[21] adc_array_wafflecap_8_8
x119 VDD ctop vcm row_n[3] rowon_n[3] net8 net7 VSS col_n[22] rowoff_n[3] col[22] adc_array_wafflecap_8_8
x120 VDD ctop vcm row_n[3] rowon_n[3] net8 net7 VSS col_n[23] rowoff_n[3] col[23] adc_array_wafflecap_8_8
x121 VDD ctop vcm row_n[3] rowon_n[3] net8 net7 VSS col_n[24] rowoff_n[3] col[24] adc_array_wafflecap_8_8
x122 VDD ctop vcm row_n[3] rowon_n[3] net8 net7 VSS col_n[25] rowoff_n[3] col[25] adc_array_wafflecap_8_8
x123 VDD ctop vcm row_n[3] rowon_n[3] net8 net7 VSS col_n[26] rowoff_n[3] col[26] adc_array_wafflecap_8_8
x124 VDD ctop vcm row_n[3] rowon_n[3] net8 net7 VSS col_n[27] rowoff_n[3] col[27] adc_array_wafflecap_8_8
x125 VDD ctop vcm row_n[3] rowon_n[3] net8 net7 VSS col_n[28] rowoff_n[3] col[28] adc_array_wafflecap_8_8
x126 VDD ctop vcm row_n[3] rowon_n[3] net8 net7 VSS col_n[29] rowoff_n[3] col[29] adc_array_wafflecap_8_8
x127 VDD ctop vcm row_n[3] rowon_n[3] net8 net7 VSS col_n[30] rowoff_n[3] col[30] adc_array_wafflecap_8_8
x128 VDD ctop vcm row_n[3] rowon_n[3] net8 net7 VSS col_n[31] rowoff_n[3] col[31] adc_array_wafflecap_8_8
x129 VDD ctop vcm row_n[4] rowon_n[4] net10 net9 VSS col_n[0] rowoff_n[4] col[0] adc_array_wafflecap_8_8
x130 VDD ctop vcm row_n[4] rowon_n[4] net10 net9 VSS col_n[1] rowoff_n[4] col[1] adc_array_wafflecap_8_8
x131 VDD ctop vcm row_n[4] rowon_n[4] net10 net9 VSS col_n[2] rowoff_n[4] col[2] adc_array_wafflecap_8_8
x132 VDD ctop vcm row_n[4] rowon_n[4] net10 net9 VSS col_n[3] rowoff_n[4] col[3] adc_array_wafflecap_8_8
x133 VDD ctop vcm row_n[4] rowon_n[4] net10 net9 VSS col_n[4] rowoff_n[4] col[4] adc_array_wafflecap_8_8
x134 VDD ctop vcm row_n[4] rowon_n[4] net10 net9 VSS col_n[5] rowoff_n[4] col[5] adc_array_wafflecap_8_8
x135 VDD ctop vcm row_n[4] rowon_n[4] net10 net9 VSS col_n[6] rowoff_n[4] col[6] adc_array_wafflecap_8_8
x136 VDD ctop vcm row_n[4] rowon_n[4] net10 net9 VSS col_n[7] rowoff_n[4] col[7] adc_array_wafflecap_8_8
x137 VDD ctop vcm row_n[4] rowon_n[4] net10 net9 VSS col_n[8] rowoff_n[4] col[8] adc_array_wafflecap_8_8
x138 VDD ctop vcm row_n[4] rowon_n[4] net10 net9 VSS col_n[9] rowoff_n[4] col[9] adc_array_wafflecap_8_8
x139 VDD ctop vcm row_n[4] rowon_n[4] net10 net9 VSS col_n[10] rowoff_n[4] col[10] adc_array_wafflecap_8_8
x140 VDD ctop vcm row_n[4] rowon_n[4] net10 net9 VSS col_n[11] rowoff_n[4] col[11] adc_array_wafflecap_8_8
x141 VDD ctop vcm row_n[4] rowon_n[4] net10 net9 VSS col_n[12] rowoff_n[4] col[12] adc_array_wafflecap_8_8
x142 VDD ctop vcm row_n[4] rowon_n[4] net10 net9 VSS col_n[13] rowoff_n[4] col[13] adc_array_wafflecap_8_8
x143 VDD ctop vcm row_n[4] rowon_n[4] net10 net9 VSS col_n[14] rowoff_n[4] col[14] adc_array_wafflecap_8_8
x144 VDD ctop vcm row_n[4] rowon_n[4] net10 net9 VSS col_n[15] rowoff_n[4] col[15] adc_array_wafflecap_8_8
x145 VDD ctop vcm row_n[4] rowon_n[4] net10 net9 VSS col_n[16] rowoff_n[4] col[16] adc_array_wafflecap_8_8
x146 VDD ctop vcm row_n[4] rowon_n[4] net10 net9 VSS col_n[17] rowoff_n[4] col[17] adc_array_wafflecap_8_8
x147 VDD ctop vcm row_n[4] rowon_n[4] net10 net9 VSS col_n[18] rowoff_n[4] col[18] adc_array_wafflecap_8_8
x148 VDD ctop vcm row_n[4] rowon_n[4] net10 net9 VSS col_n[19] rowoff_n[4] col[19] adc_array_wafflecap_8_8
x149 VDD ctop vcm row_n[4] rowon_n[4] net10 net9 VSS col_n[20] rowoff_n[4] col[20] adc_array_wafflecap_8_8
x150 VDD ctop vcm row_n[4] rowon_n[4] net10 net9 VSS col_n[21] rowoff_n[4] col[21] adc_array_wafflecap_8_8
x151 VDD ctop vcm row_n[4] rowon_n[4] net10 net9 VSS col_n[22] rowoff_n[4] col[22] adc_array_wafflecap_8_8
x152 VDD ctop vcm row_n[4] rowon_n[4] net10 net9 VSS col_n[23] rowoff_n[4] col[23] adc_array_wafflecap_8_8
x153 VDD ctop vcm row_n[4] rowon_n[4] net10 net9 VSS col_n[24] rowoff_n[4] col[24] adc_array_wafflecap_8_8
x154 VDD ctop vcm row_n[4] rowon_n[4] net10 net9 VSS col_n[25] rowoff_n[4] col[25] adc_array_wafflecap_8_8
x155 VDD ctop vcm row_n[4] rowon_n[4] net10 net9 VSS col_n[26] rowoff_n[4] col[26] adc_array_wafflecap_8_8
x156 VDD ctop vcm row_n[4] rowon_n[4] net10 net9 VSS col_n[27] rowoff_n[4] col[27] adc_array_wafflecap_8_8
x157 VDD ctop vcm row_n[4] rowon_n[4] net10 net9 VSS col_n[28] rowoff_n[4] col[28] adc_array_wafflecap_8_8
x158 VDD ctop vcm row_n[4] rowon_n[4] net10 net9 VSS col_n[29] rowoff_n[4] col[29] adc_array_wafflecap_8_8
x159 VDD ctop vcm row_n[4] rowon_n[4] net10 net9 VSS col_n[30] rowoff_n[4] col[30] adc_array_wafflecap_8_8
x160 VDD ctop vcm row_n[4] rowon_n[4] net10 net9 VSS col_n[31] rowoff_n[4] col[31] adc_array_wafflecap_8_8
x161 VDD ctop vcm row_n[5] rowon_n[5] net12 net11 VSS col_n[0] rowoff_n[5] col[0] adc_array_wafflecap_8_8
x162 VDD ctop vcm row_n[5] rowon_n[5] net12 net11 VSS col_n[1] rowoff_n[5] col[1] adc_array_wafflecap_8_8
x163 VDD ctop vcm row_n[5] rowon_n[5] net12 net11 VSS col_n[2] rowoff_n[5] col[2] adc_array_wafflecap_8_8
x164 VDD ctop vcm row_n[5] rowon_n[5] net12 net11 VSS col_n[3] rowoff_n[5] col[3] adc_array_wafflecap_8_8
x165 VDD ctop vcm row_n[5] rowon_n[5] net12 net11 VSS col_n[4] rowoff_n[5] col[4] adc_array_wafflecap_8_8
x166 VDD ctop vcm row_n[5] rowon_n[5] net12 net11 VSS col_n[5] rowoff_n[5] col[5] adc_array_wafflecap_8_8
x167 VDD ctop vcm row_n[5] rowon_n[5] net12 net11 VSS col_n[6] rowoff_n[5] col[6] adc_array_wafflecap_8_8
x168 VDD ctop vcm row_n[5] rowon_n[5] net12 net11 VSS col_n[7] rowoff_n[5] col[7] adc_array_wafflecap_8_8
x169 VDD ctop vcm row_n[5] rowon_n[5] net12 net11 VSS col_n[8] rowoff_n[5] col[8] adc_array_wafflecap_8_8
x170 VDD ctop vcm row_n[5] rowon_n[5] net12 net11 VSS col_n[9] rowoff_n[5] col[9] adc_array_wafflecap_8_8
x171 VDD ctop vcm row_n[5] rowon_n[5] net12 net11 VSS col_n[10] rowoff_n[5] col[10] adc_array_wafflecap_8_8
x172 VDD ctop vcm row_n[5] rowon_n[5] net12 net11 VSS col_n[11] rowoff_n[5] col[11] adc_array_wafflecap_8_8
x173 VDD ctop vcm row_n[5] rowon_n[5] net12 net11 VSS col_n[12] rowoff_n[5] col[12] adc_array_wafflecap_8_8
x174 VDD ctop vcm row_n[5] rowon_n[5] net12 net11 VSS col_n[13] rowoff_n[5] col[13] adc_array_wafflecap_8_8
x175 VDD ctop vcm row_n[5] rowon_n[5] net12 net11 VSS col_n[14] rowoff_n[5] col[14] adc_array_wafflecap_8_8
x176 VDD ctop vcm row_n[5] rowon_n[5] net12 net11 VSS col_n[15] rowoff_n[5] col[15] adc_array_wafflecap_8_8
x177 VDD ctop vcm row_n[5] rowon_n[5] net12 net11 VSS col_n[16] rowoff_n[5] col[16] adc_array_wafflecap_8_8
x178 VDD ctop vcm row_n[5] rowon_n[5] net12 net11 VSS col_n[17] rowoff_n[5] col[17] adc_array_wafflecap_8_8
x179 VDD ctop vcm row_n[5] rowon_n[5] net12 net11 VSS col_n[18] rowoff_n[5] col[18] adc_array_wafflecap_8_8
x180 VDD ctop vcm row_n[5] rowon_n[5] net12 net11 VSS col_n[19] rowoff_n[5] col[19] adc_array_wafflecap_8_8
x181 VDD ctop vcm row_n[5] rowon_n[5] net12 net11 VSS col_n[20] rowoff_n[5] col[20] adc_array_wafflecap_8_8
x182 VDD ctop vcm row_n[5] rowon_n[5] net12 net11 VSS col_n[21] rowoff_n[5] col[21] adc_array_wafflecap_8_8
x183 VDD ctop vcm row_n[5] rowon_n[5] net12 net11 VSS col_n[22] rowoff_n[5] col[22] adc_array_wafflecap_8_8
x184 VDD ctop vcm row_n[5] rowon_n[5] net12 net11 VSS col_n[23] rowoff_n[5] col[23] adc_array_wafflecap_8_8
x185 VDD ctop vcm row_n[5] rowon_n[5] net12 net11 VSS col_n[24] rowoff_n[5] col[24] adc_array_wafflecap_8_8
x186 VDD ctop vcm row_n[5] rowon_n[5] net12 net11 VSS col_n[25] rowoff_n[5] col[25] adc_array_wafflecap_8_8
x187 VDD ctop vcm row_n[5] rowon_n[5] net12 net11 VSS col_n[26] rowoff_n[5] col[26] adc_array_wafflecap_8_8
x188 VDD ctop vcm row_n[5] rowon_n[5] net12 net11 VSS col_n[27] rowoff_n[5] col[27] adc_array_wafflecap_8_8
x189 VDD ctop vcm row_n[5] rowon_n[5] net12 net11 VSS col_n[28] rowoff_n[5] col[28] adc_array_wafflecap_8_8
x190 VDD ctop vcm row_n[5] rowon_n[5] net12 net11 VSS col_n[29] rowoff_n[5] col[29] adc_array_wafflecap_8_8
x191 VDD ctop vcm row_n[5] rowon_n[5] net12 net11 VSS col_n[30] rowoff_n[5] col[30] adc_array_wafflecap_8_8
x192 VDD ctop vcm row_n[5] rowon_n[5] net12 net11 VSS col_n[31] rowoff_n[5] col[31] adc_array_wafflecap_8_8
x193 VDD ctop vcm row_n[6] rowon_n[6] net14 net13 VSS col_n[0] rowoff_n[6] col[0] adc_array_wafflecap_8_8
x194 VDD ctop vcm row_n[6] rowon_n[6] net14 net13 VSS col_n[1] rowoff_n[6] col[1] adc_array_wafflecap_8_8
x195 VDD ctop vcm row_n[6] rowon_n[6] net14 net13 VSS col_n[2] rowoff_n[6] col[2] adc_array_wafflecap_8_8
x196 VDD ctop vcm row_n[6] rowon_n[6] net14 net13 VSS col_n[3] rowoff_n[6] col[3] adc_array_wafflecap_8_8
x197 VDD ctop vcm row_n[6] rowon_n[6] net14 net13 VSS col_n[4] rowoff_n[6] col[4] adc_array_wafflecap_8_8
x198 VDD ctop vcm row_n[6] rowon_n[6] net14 net13 VSS col_n[5] rowoff_n[6] col[5] adc_array_wafflecap_8_8
x199 VDD ctop vcm row_n[6] rowon_n[6] net14 net13 VSS col_n[6] rowoff_n[6] col[6] adc_array_wafflecap_8_8
x200 VDD ctop vcm row_n[6] rowon_n[6] net14 net13 VSS col_n[7] rowoff_n[6] col[7] adc_array_wafflecap_8_8
x201 VDD ctop vcm row_n[6] rowon_n[6] net14 net13 VSS col_n[8] rowoff_n[6] col[8] adc_array_wafflecap_8_8
x202 VDD ctop vcm row_n[6] rowon_n[6] net14 net13 VSS col_n[9] rowoff_n[6] col[9] adc_array_wafflecap_8_8
x203 VDD ctop vcm row_n[6] rowon_n[6] net14 net13 VSS col_n[10] rowoff_n[6] col[10] adc_array_wafflecap_8_8
x204 VDD ctop vcm row_n[6] rowon_n[6] net14 net13 VSS col_n[11] rowoff_n[6] col[11] adc_array_wafflecap_8_8
x205 VDD ctop vcm row_n[6] rowon_n[6] net14 net13 VSS col_n[12] rowoff_n[6] col[12] adc_array_wafflecap_8_8
x206 VDD ctop vcm row_n[6] rowon_n[6] net14 net13 VSS col_n[13] rowoff_n[6] col[13] adc_array_wafflecap_8_8
x207 VDD ctop vcm row_n[6] rowon_n[6] net14 net13 VSS col_n[14] rowoff_n[6] col[14] adc_array_wafflecap_8_8
x208 VDD ctop vcm row_n[6] rowon_n[6] net14 net13 VSS col_n[15] rowoff_n[6] col[15] adc_array_wafflecap_8_8
x209 VDD ctop vcm row_n[6] rowon_n[6] net14 net13 VSS col_n[16] rowoff_n[6] col[16] adc_array_wafflecap_8_8
x210 VDD ctop vcm row_n[6] rowon_n[6] net14 net13 VSS col_n[17] rowoff_n[6] col[17] adc_array_wafflecap_8_8
x211 VDD ctop vcm row_n[6] rowon_n[6] net14 net13 VSS col_n[18] rowoff_n[6] col[18] adc_array_wafflecap_8_8
x212 VDD ctop vcm row_n[6] rowon_n[6] net14 net13 VSS col_n[19] rowoff_n[6] col[19] adc_array_wafflecap_8_8
x213 VDD ctop vcm row_n[6] rowon_n[6] net14 net13 VSS col_n[20] rowoff_n[6] col[20] adc_array_wafflecap_8_8
x214 VDD ctop vcm row_n[6] rowon_n[6] net14 net13 VSS col_n[21] rowoff_n[6] col[21] adc_array_wafflecap_8_8
x215 VDD ctop vcm row_n[6] rowon_n[6] net14 net13 VSS col_n[22] rowoff_n[6] col[22] adc_array_wafflecap_8_8
x216 VDD ctop vcm row_n[6] rowon_n[6] net14 net13 VSS col_n[23] rowoff_n[6] col[23] adc_array_wafflecap_8_8
x217 VDD ctop vcm row_n[6] rowon_n[6] net14 net13 VSS col_n[24] rowoff_n[6] col[24] adc_array_wafflecap_8_8
x218 VDD ctop vcm row_n[6] rowon_n[6] net14 net13 VSS col_n[25] rowoff_n[6] col[25] adc_array_wafflecap_8_8
x219 VDD ctop vcm row_n[6] rowon_n[6] net14 net13 VSS col_n[26] rowoff_n[6] col[26] adc_array_wafflecap_8_8
x220 VDD ctop vcm row_n[6] rowon_n[6] net14 net13 VSS col_n[27] rowoff_n[6] col[27] adc_array_wafflecap_8_8
x221 VDD ctop vcm row_n[6] rowon_n[6] net14 net13 VSS col_n[28] rowoff_n[6] col[28] adc_array_wafflecap_8_8
x222 VDD ctop vcm row_n[6] rowon_n[6] net14 net13 VSS col_n[29] rowoff_n[6] col[29] adc_array_wafflecap_8_8
x223 VDD ctop vcm row_n[6] rowon_n[6] net14 net13 VSS col_n[30] rowoff_n[6] col[30] adc_array_wafflecap_8_8
x224 VDD ctop vcm row_n[6] rowon_n[6] net14 net13 VSS col_n[31] rowoff_n[6] col[31] adc_array_wafflecap_8_8
x225 VDD ctop vcm row_n[7] rowon_n[7] net16 net15 VSS col_n[0] rowoff_n[7] col[0] adc_array_wafflecap_8_8
x226 VDD ctop vcm row_n[7] rowon_n[7] net16 net15 VSS col_n[1] rowoff_n[7] col[1] adc_array_wafflecap_8_8
x227 VDD ctop vcm row_n[7] rowon_n[7] net16 net15 VSS col_n[2] rowoff_n[7] col[2] adc_array_wafflecap_8_8
x228 VDD ctop vcm row_n[7] rowon_n[7] net16 net15 VSS col_n[3] rowoff_n[7] col[3] adc_array_wafflecap_8_8
x229 VDD ctop vcm row_n[7] rowon_n[7] net16 net15 VSS col_n[4] rowoff_n[7] col[4] adc_array_wafflecap_8_8
x230 VDD ctop vcm row_n[7] rowon_n[7] net16 net15 VSS col_n[5] rowoff_n[7] col[5] adc_array_wafflecap_8_8
x231 VDD ctop vcm row_n[7] rowon_n[7] net16 net15 VSS col_n[6] rowoff_n[7] col[6] adc_array_wafflecap_8_8
x232 VDD ctop vcm row_n[7] rowon_n[7] net16 net15 VSS col_n[7] rowoff_n[7] col[7] adc_array_wafflecap_8_8
x233 VDD ctop vcm row_n[7] rowon_n[7] net16 net15 VSS col_n[8] rowoff_n[7] col[8] adc_array_wafflecap_8_8
x234 VDD ctop vcm row_n[7] rowon_n[7] net16 net15 VSS col_n[9] rowoff_n[7] col[9] adc_array_wafflecap_8_8
x235 VDD ctop vcm row_n[7] rowon_n[7] net16 net15 VSS col_n[10] rowoff_n[7] col[10] adc_array_wafflecap_8_8
x236 VDD ctop vcm row_n[7] rowon_n[7] net16 net15 VSS col_n[11] rowoff_n[7] col[11] adc_array_wafflecap_8_8
x237 VDD ctop vcm row_n[7] rowon_n[7] net16 net15 VSS col_n[12] rowoff_n[7] col[12] adc_array_wafflecap_8_8
x238 VDD ctop vcm row_n[7] rowon_n[7] net16 net15 VSS col_n[13] rowoff_n[7] col[13] adc_array_wafflecap_8_8
x239 VDD ctop vcm row_n[7] rowon_n[7] net16 net15 VSS col_n[14] rowoff_n[7] col[14] adc_array_wafflecap_8_8
x240 VDD ctop vcm row_n[7] rowon_n[7] net16 net15 VSS col_n[15] rowoff_n[7] col[15] adc_array_wafflecap_8_8
x241 VDD ctop vcm row_n[7] rowon_n[7] net16 net15 VSS col_n[16] rowoff_n[7] col[16] adc_array_wafflecap_8_8
x242 VDD ctop vcm row_n[7] rowon_n[7] net16 net15 VSS col_n[17] rowoff_n[7] col[17] adc_array_wafflecap_8_8
x243 VDD ctop vcm row_n[7] rowon_n[7] net16 net15 VSS col_n[18] rowoff_n[7] col[18] adc_array_wafflecap_8_8
x244 VDD ctop vcm row_n[7] rowon_n[7] net16 net15 VSS col_n[19] rowoff_n[7] col[19] adc_array_wafflecap_8_8
x245 VDD ctop vcm row_n[7] rowon_n[7] net16 net15 VSS col_n[20] rowoff_n[7] col[20] adc_array_wafflecap_8_8
x246 VDD ctop vcm row_n[7] rowon_n[7] net16 net15 VSS col_n[21] rowoff_n[7] col[21] adc_array_wafflecap_8_8
x247 VDD ctop vcm row_n[7] rowon_n[7] net16 net15 VSS col_n[22] rowoff_n[7] col[22] adc_array_wafflecap_8_8
x248 VDD ctop vcm row_n[7] rowon_n[7] net16 net15 VSS col_n[23] rowoff_n[7] col[23] adc_array_wafflecap_8_8
x249 VDD ctop vcm row_n[7] rowon_n[7] net16 net15 VSS col_n[24] rowoff_n[7] col[24] adc_array_wafflecap_8_8
x250 VDD ctop vcm row_n[7] rowon_n[7] net16 net15 VSS col_n[25] rowoff_n[7] col[25] adc_array_wafflecap_8_8
x251 VDD ctop vcm row_n[7] rowon_n[7] net16 net15 VSS col_n[26] rowoff_n[7] col[26] adc_array_wafflecap_8_8
x252 VDD ctop vcm row_n[7] rowon_n[7] net16 net15 VSS col_n[27] rowoff_n[7] col[27] adc_array_wafflecap_8_8
x253 VDD ctop vcm row_n[7] rowon_n[7] net16 net15 VSS col_n[28] rowoff_n[7] col[28] adc_array_wafflecap_8_8
x254 VDD ctop vcm row_n[7] rowon_n[7] net16 net15 VSS col_n[29] rowoff_n[7] col[29] adc_array_wafflecap_8_8
x255 VDD ctop vcm row_n[7] rowon_n[7] net16 net15 VSS col_n[30] rowoff_n[7] col[30] adc_array_wafflecap_8_8
x256 VDD ctop vcm row_n[7] rowon_n[7] net16 net15 VSS col_n[31] rowoff_n[7] col[31] adc_array_wafflecap_8_8
x257 VDD ctop vcm row_n[8] rowon_n[8] net18 net17 VSS col_n[0] rowoff_n[8] col[0] adc_array_wafflecap_8_8
x258 VDD ctop vcm row_n[8] rowon_n[8] net18 net17 VSS col_n[1] rowoff_n[8] col[1] adc_array_wafflecap_8_8
x259 VDD ctop vcm row_n[8] rowon_n[8] net18 net17 VSS col_n[2] rowoff_n[8] col[2] adc_array_wafflecap_8_8
x260 VDD ctop vcm row_n[8] rowon_n[8] net18 net17 VSS col_n[3] rowoff_n[8] col[3] adc_array_wafflecap_8_8
x261 VDD ctop vcm row_n[8] rowon_n[8] net18 net17 VSS col_n[4] rowoff_n[8] col[4] adc_array_wafflecap_8_8
x262 VDD ctop vcm row_n[8] rowon_n[8] net18 net17 VSS col_n[5] rowoff_n[8] col[5] adc_array_wafflecap_8_8
x263 VDD ctop vcm row_n[8] rowon_n[8] net18 net17 VSS col_n[6] rowoff_n[8] col[6] adc_array_wafflecap_8_8
x264 VDD ctop vcm row_n[8] rowon_n[8] net18 net17 VSS col_n[7] rowoff_n[8] col[7] adc_array_wafflecap_8_8
x265 VDD ctop vcm row_n[8] rowon_n[8] net18 net17 VSS col_n[8] rowoff_n[8] col[8] adc_array_wafflecap_8_8
x266 VDD ctop vcm row_n[8] rowon_n[8] net18 net17 VSS col_n[9] rowoff_n[8] col[9] adc_array_wafflecap_8_8
x267 VDD ctop vcm row_n[8] rowon_n[8] net18 net17 VSS col_n[10] rowoff_n[8] col[10] adc_array_wafflecap_8_8
x268 VDD ctop vcm row_n[8] rowon_n[8] net18 net17 VSS col_n[11] rowoff_n[8] col[11] adc_array_wafflecap_8_8
x269 VDD ctop vcm row_n[8] rowon_n[8] net18 net17 VSS col_n[12] rowoff_n[8] col[12] adc_array_wafflecap_8_8
x270 VDD ctop vcm row_n[8] rowon_n[8] net18 net17 VSS col_n[13] rowoff_n[8] col[13] adc_array_wafflecap_8_8
x271 VDD ctop vcm row_n[8] rowon_n[8] net18 net17 VSS col_n[14] rowoff_n[8] col[14] adc_array_wafflecap_8_8
x272 VDD ctop vcm row_n[8] rowon_n[8] net18 net17 VSS col_n[15] rowoff_n[8] col[15] adc_array_wafflecap_8_8
x273 VDD ctop vcm row_n[8] rowon_n[8] net18 net17 VSS col_n[16] rowoff_n[8] col[16] adc_array_wafflecap_8_8
x274 VDD ctop vcm row_n[8] rowon_n[8] net18 net17 VSS col_n[17] rowoff_n[8] col[17] adc_array_wafflecap_8_8
x275 VDD ctop vcm row_n[8] rowon_n[8] net18 net17 VSS col_n[18] rowoff_n[8] col[18] adc_array_wafflecap_8_8
x276 VDD ctop vcm row_n[8] rowon_n[8] net18 net17 VSS col_n[19] rowoff_n[8] col[19] adc_array_wafflecap_8_8
x277 VDD ctop vcm row_n[8] rowon_n[8] net18 net17 VSS col_n[20] rowoff_n[8] col[20] adc_array_wafflecap_8_8
x278 VDD ctop vcm row_n[8] rowon_n[8] net18 net17 VSS col_n[21] rowoff_n[8] col[21] adc_array_wafflecap_8_8
x279 VDD ctop vcm row_n[8] rowon_n[8] net18 net17 VSS col_n[22] rowoff_n[8] col[22] adc_array_wafflecap_8_8
x280 VDD ctop vcm row_n[8] rowon_n[8] net18 net17 VSS col_n[23] rowoff_n[8] col[23] adc_array_wafflecap_8_8
x281 VDD ctop vcm row_n[8] rowon_n[8] net18 net17 VSS col_n[24] rowoff_n[8] col[24] adc_array_wafflecap_8_8
x282 VDD ctop vcm row_n[8] rowon_n[8] net18 net17 VSS col_n[25] rowoff_n[8] col[25] adc_array_wafflecap_8_8
x283 VDD ctop vcm row_n[8] rowon_n[8] net18 net17 VSS col_n[26] rowoff_n[8] col[26] adc_array_wafflecap_8_8
x284 VDD ctop vcm row_n[8] rowon_n[8] net18 net17 VSS col_n[27] rowoff_n[8] col[27] adc_array_wafflecap_8_8
x285 VDD ctop vcm row_n[8] rowon_n[8] net18 net17 VSS col_n[28] rowoff_n[8] col[28] adc_array_wafflecap_8_8
x286 VDD ctop vcm row_n[8] rowon_n[8] net18 net17 VSS col_n[29] rowoff_n[8] col[29] adc_array_wafflecap_8_8
x287 VDD ctop vcm row_n[8] rowon_n[8] net18 net17 VSS col_n[30] rowoff_n[8] col[30] adc_array_wafflecap_8_8
x288 VDD ctop vcm row_n[8] rowon_n[8] net18 net17 VSS col_n[31] rowoff_n[8] col[31] adc_array_wafflecap_8_8
x289 VDD ctop vcm row_n[9] rowon_n[9] net20 net19 VSS col_n[0] rowoff_n[9] col[0] adc_array_wafflecap_8_8
x290 VDD ctop vcm row_n[9] rowon_n[9] net20 net19 VSS col_n[1] rowoff_n[9] col[1] adc_array_wafflecap_8_8
x291 VDD ctop vcm row_n[9] rowon_n[9] net20 net19 VSS col_n[2] rowoff_n[9] col[2] adc_array_wafflecap_8_8
x292 VDD ctop vcm row_n[9] rowon_n[9] net20 net19 VSS col_n[3] rowoff_n[9] col[3] adc_array_wafflecap_8_8
x293 VDD ctop vcm row_n[9] rowon_n[9] net20 net19 VSS col_n[4] rowoff_n[9] col[4] adc_array_wafflecap_8_8
x294 VDD ctop vcm row_n[9] rowon_n[9] net20 net19 VSS col_n[5] rowoff_n[9] col[5] adc_array_wafflecap_8_8
x295 VDD ctop vcm row_n[9] rowon_n[9] net20 net19 VSS col_n[6] rowoff_n[9] col[6] adc_array_wafflecap_8_8
x296 VDD ctop vcm row_n[9] rowon_n[9] net20 net19 VSS col_n[7] rowoff_n[9] col[7] adc_array_wafflecap_8_8
x297 VDD ctop vcm row_n[9] rowon_n[9] net20 net19 VSS col_n[8] rowoff_n[9] col[8] adc_array_wafflecap_8_8
x298 VDD ctop vcm row_n[9] rowon_n[9] net20 net19 VSS col_n[9] rowoff_n[9] col[9] adc_array_wafflecap_8_8
x299 VDD ctop vcm row_n[9] rowon_n[9] net20 net19 VSS col_n[10] rowoff_n[9] col[10] adc_array_wafflecap_8_8
x300 VDD ctop vcm row_n[9] rowon_n[9] net20 net19 VSS col_n[11] rowoff_n[9] col[11] adc_array_wafflecap_8_8
x301 VDD ctop vcm row_n[9] rowon_n[9] net20 net19 VSS col_n[12] rowoff_n[9] col[12] adc_array_wafflecap_8_8
x302 VDD ctop vcm row_n[9] rowon_n[9] net20 net19 VSS col_n[13] rowoff_n[9] col[13] adc_array_wafflecap_8_8
x303 VDD ctop vcm row_n[9] rowon_n[9] net20 net19 VSS col_n[14] rowoff_n[9] col[14] adc_array_wafflecap_8_8
x304 VDD ctop vcm row_n[9] rowon_n[9] net20 net19 VSS col_n[15] rowoff_n[9] col[15] adc_array_wafflecap_8_8
x305 VDD ctop vcm row_n[9] rowon_n[9] net20 net19 VSS col_n[16] rowoff_n[9] col[16] adc_array_wafflecap_8_8
x306 VDD ctop vcm row_n[9] rowon_n[9] net20 net19 VSS col_n[17] rowoff_n[9] col[17] adc_array_wafflecap_8_8
x307 VDD ctop vcm row_n[9] rowon_n[9] net20 net19 VSS col_n[18] rowoff_n[9] col[18] adc_array_wafflecap_8_8
x308 VDD ctop vcm row_n[9] rowon_n[9] net20 net19 VSS col_n[19] rowoff_n[9] col[19] adc_array_wafflecap_8_8
x309 VDD ctop vcm row_n[9] rowon_n[9] net20 net19 VSS col_n[20] rowoff_n[9] col[20] adc_array_wafflecap_8_8
x310 VDD ctop vcm row_n[9] rowon_n[9] net20 net19 VSS col_n[21] rowoff_n[9] col[21] adc_array_wafflecap_8_8
x311 VDD ctop vcm row_n[9] rowon_n[9] net20 net19 VSS col_n[22] rowoff_n[9] col[22] adc_array_wafflecap_8_8
x312 VDD ctop vcm row_n[9] rowon_n[9] net20 net19 VSS col_n[23] rowoff_n[9] col[23] adc_array_wafflecap_8_8
x313 VDD ctop vcm row_n[9] rowon_n[9] net20 net19 VSS col_n[24] rowoff_n[9] col[24] adc_array_wafflecap_8_8
x314 VDD ctop vcm row_n[9] rowon_n[9] net20 net19 VSS col_n[25] rowoff_n[9] col[25] adc_array_wafflecap_8_8
x315 VDD ctop vcm row_n[9] rowon_n[9] net20 net19 VSS col_n[26] rowoff_n[9] col[26] adc_array_wafflecap_8_8
x316 VDD ctop vcm row_n[9] rowon_n[9] net20 net19 VSS col_n[27] rowoff_n[9] col[27] adc_array_wafflecap_8_8
x317 VDD ctop vcm row_n[9] rowon_n[9] net20 net19 VSS col_n[28] rowoff_n[9] col[28] adc_array_wafflecap_8_8
x318 VDD ctop vcm row_n[9] rowon_n[9] net20 net19 VSS col_n[29] rowoff_n[9] col[29] adc_array_wafflecap_8_8
x319 VDD ctop vcm row_n[9] rowon_n[9] net20 net19 VSS col_n[30] rowoff_n[9] col[30] adc_array_wafflecap_8_8
x320 VDD ctop vcm row_n[9] rowon_n[9] net20 net19 VSS col_n[31] rowoff_n[9] col[31] adc_array_wafflecap_8_8
x321 VDD ctop vcm row_n[10] rowon_n[10] net22 net21 VSS col_n[0] rowoff_n[10] col[0] adc_array_wafflecap_8_8
x322 VDD ctop vcm row_n[10] rowon_n[10] net22 net21 VSS col_n[1] rowoff_n[10] col[1] adc_array_wafflecap_8_8
x323 VDD ctop vcm row_n[10] rowon_n[10] net22 net21 VSS col_n[2] rowoff_n[10] col[2] adc_array_wafflecap_8_8
x324 VDD ctop vcm row_n[10] rowon_n[10] net22 net21 VSS col_n[3] rowoff_n[10] col[3] adc_array_wafflecap_8_8
x325 VDD ctop vcm row_n[10] rowon_n[10] net22 net21 VSS col_n[4] rowoff_n[10] col[4] adc_array_wafflecap_8_8
x326 VDD ctop vcm row_n[10] rowon_n[10] net22 net21 VSS col_n[5] rowoff_n[10] col[5] adc_array_wafflecap_8_8
x327 VDD ctop vcm row_n[10] rowon_n[10] net22 net21 VSS col_n[6] rowoff_n[10] col[6] adc_array_wafflecap_8_8
x328 VDD ctop vcm row_n[10] rowon_n[10] net22 net21 VSS col_n[7] rowoff_n[10] col[7] adc_array_wafflecap_8_8
x329 VDD ctop vcm row_n[10] rowon_n[10] net22 net21 VSS col_n[8] rowoff_n[10] col[8] adc_array_wafflecap_8_8
x330 VDD ctop vcm row_n[10] rowon_n[10] net22 net21 VSS col_n[9] rowoff_n[10] col[9] adc_array_wafflecap_8_8
x331 VDD ctop vcm row_n[10] rowon_n[10] net22 net21 VSS col_n[10] rowoff_n[10] col[10] adc_array_wafflecap_8_8
x332 VDD ctop vcm row_n[10] rowon_n[10] net22 net21 VSS col_n[11] rowoff_n[10] col[11] adc_array_wafflecap_8_8
x333 VDD ctop vcm row_n[10] rowon_n[10] net22 net21 VSS col_n[12] rowoff_n[10] col[12] adc_array_wafflecap_8_8
x334 VDD ctop vcm row_n[10] rowon_n[10] net22 net21 VSS col_n[13] rowoff_n[10] col[13] adc_array_wafflecap_8_8
x335 VDD ctop vcm row_n[10] rowon_n[10] net22 net21 VSS col_n[14] rowoff_n[10] col[14] adc_array_wafflecap_8_8
x336 VDD ctop vcm row_n[10] rowon_n[10] net22 net21 VSS col_n[15] rowoff_n[10] col[15] adc_array_wafflecap_8_8
x337 VDD ctop vcm row_n[10] rowon_n[10] net22 net21 VSS col_n[16] rowoff_n[10] col[16] adc_array_wafflecap_8_8
x338 VDD ctop vcm row_n[10] rowon_n[10] net22 net21 VSS col_n[17] rowoff_n[10] col[17] adc_array_wafflecap_8_8
x339 VDD ctop vcm row_n[10] rowon_n[10] net22 net21 VSS col_n[18] rowoff_n[10] col[18] adc_array_wafflecap_8_8
x340 VDD ctop vcm row_n[10] rowon_n[10] net22 net21 VSS col_n[19] rowoff_n[10] col[19] adc_array_wafflecap_8_8
x341 VDD ctop vcm row_n[10] rowon_n[10] net22 net21 VSS col_n[20] rowoff_n[10] col[20] adc_array_wafflecap_8_8
x342 VDD ctop vcm row_n[10] rowon_n[10] net22 net21 VSS col_n[21] rowoff_n[10] col[21] adc_array_wafflecap_8_8
x343 VDD ctop vcm row_n[10] rowon_n[10] net22 net21 VSS col_n[22] rowoff_n[10] col[22] adc_array_wafflecap_8_8
x344 VDD ctop vcm row_n[10] rowon_n[10] net22 net21 VSS col_n[23] rowoff_n[10] col[23] adc_array_wafflecap_8_8
x345 VDD ctop vcm row_n[10] rowon_n[10] net22 net21 VSS col_n[24] rowoff_n[10] col[24] adc_array_wafflecap_8_8
x346 VDD ctop vcm row_n[10] rowon_n[10] net22 net21 VSS col_n[25] rowoff_n[10] col[25] adc_array_wafflecap_8_8
x347 VDD ctop vcm row_n[10] rowon_n[10] net22 net21 VSS col_n[26] rowoff_n[10] col[26] adc_array_wafflecap_8_8
x348 VDD ctop vcm row_n[10] rowon_n[10] net22 net21 VSS col_n[27] rowoff_n[10] col[27] adc_array_wafflecap_8_8
x349 VDD ctop vcm row_n[10] rowon_n[10] net22 net21 VSS col_n[28] rowoff_n[10] col[28] adc_array_wafflecap_8_8
x350 VDD ctop vcm row_n[10] rowon_n[10] net22 net21 VSS col_n[29] rowoff_n[10] col[29] adc_array_wafflecap_8_8
x351 VDD ctop vcm row_n[10] rowon_n[10] net22 net21 VSS col_n[30] rowoff_n[10] col[30] adc_array_wafflecap_8_8
x352 VDD ctop vcm row_n[10] rowon_n[10] net22 net21 VSS col_n[31] rowoff_n[10] col[31] adc_array_wafflecap_8_8
x353 VDD ctop vcm row_n[11] rowon_n[11] net24 net23 VSS col_n[0] rowoff_n[11] col[0] adc_array_wafflecap_8_8
x354 VDD ctop vcm row_n[11] rowon_n[11] net24 net23 VSS col_n[1] rowoff_n[11] col[1] adc_array_wafflecap_8_8
x355 VDD ctop vcm row_n[11] rowon_n[11] net24 net23 VSS col_n[2] rowoff_n[11] col[2] adc_array_wafflecap_8_8
x356 VDD ctop vcm row_n[11] rowon_n[11] net24 net23 VSS col_n[3] rowoff_n[11] col[3] adc_array_wafflecap_8_8
x357 VDD ctop vcm row_n[11] rowon_n[11] net24 net23 VSS col_n[4] rowoff_n[11] col[4] adc_array_wafflecap_8_8
x358 VDD ctop vcm row_n[11] rowon_n[11] net24 net23 VSS col_n[5] rowoff_n[11] col[5] adc_array_wafflecap_8_8
x359 VDD ctop vcm row_n[11] rowon_n[11] net24 net23 VSS col_n[6] rowoff_n[11] col[6] adc_array_wafflecap_8_8
x360 VDD ctop vcm row_n[11] rowon_n[11] net24 net23 VSS col_n[7] rowoff_n[11] col[7] adc_array_wafflecap_8_8
x361 VDD ctop vcm row_n[11] rowon_n[11] net24 net23 VSS col_n[8] rowoff_n[11] col[8] adc_array_wafflecap_8_8
x362 VDD ctop vcm row_n[11] rowon_n[11] net24 net23 VSS col_n[9] rowoff_n[11] col[9] adc_array_wafflecap_8_8
x363 VDD ctop vcm row_n[11] rowon_n[11] net24 net23 VSS col_n[10] rowoff_n[11] col[10] adc_array_wafflecap_8_8
x364 VDD ctop vcm row_n[11] rowon_n[11] net24 net23 VSS col_n[11] rowoff_n[11] col[11] adc_array_wafflecap_8_8
x365 VDD ctop vcm row_n[11] rowon_n[11] net24 net23 VSS col_n[12] rowoff_n[11] col[12] adc_array_wafflecap_8_8
x366 VDD ctop vcm row_n[11] rowon_n[11] net24 net23 VSS col_n[13] rowoff_n[11] col[13] adc_array_wafflecap_8_8
x367 VDD ctop vcm row_n[11] rowon_n[11] net24 net23 VSS col_n[14] rowoff_n[11] col[14] adc_array_wafflecap_8_8
x368 VDD ctop vcm row_n[11] rowon_n[11] net24 net23 VSS col_n[15] rowoff_n[11] col[15] adc_array_wafflecap_8_8
x369 VDD ctop vcm row_n[11] rowon_n[11] net24 net23 VSS col_n[16] rowoff_n[11] col[16] adc_array_wafflecap_8_8
x370 VDD ctop vcm row_n[11] rowon_n[11] net24 net23 VSS col_n[17] rowoff_n[11] col[17] adc_array_wafflecap_8_8
x371 VDD ctop vcm row_n[11] rowon_n[11] net24 net23 VSS col_n[18] rowoff_n[11] col[18] adc_array_wafflecap_8_8
x372 VDD ctop vcm row_n[11] rowon_n[11] net24 net23 VSS col_n[19] rowoff_n[11] col[19] adc_array_wafflecap_8_8
x373 VDD ctop vcm row_n[11] rowon_n[11] net24 net23 VSS col_n[20] rowoff_n[11] col[20] adc_array_wafflecap_8_8
x374 VDD ctop vcm row_n[11] rowon_n[11] net24 net23 VSS col_n[21] rowoff_n[11] col[21] adc_array_wafflecap_8_8
x375 VDD ctop vcm row_n[11] rowon_n[11] net24 net23 VSS col_n[22] rowoff_n[11] col[22] adc_array_wafflecap_8_8
x376 VDD ctop vcm row_n[11] rowon_n[11] net24 net23 VSS col_n[23] rowoff_n[11] col[23] adc_array_wafflecap_8_8
x377 VDD ctop vcm row_n[11] rowon_n[11] net24 net23 VSS col_n[24] rowoff_n[11] col[24] adc_array_wafflecap_8_8
x378 VDD ctop vcm row_n[11] rowon_n[11] net24 net23 VSS col_n[25] rowoff_n[11] col[25] adc_array_wafflecap_8_8
x379 VDD ctop vcm row_n[11] rowon_n[11] net24 net23 VSS col_n[26] rowoff_n[11] col[26] adc_array_wafflecap_8_8
x380 VDD ctop vcm row_n[11] rowon_n[11] net24 net23 VSS col_n[27] rowoff_n[11] col[27] adc_array_wafflecap_8_8
x381 VDD ctop vcm row_n[11] rowon_n[11] net24 net23 VSS col_n[28] rowoff_n[11] col[28] adc_array_wafflecap_8_8
x382 VDD ctop vcm row_n[11] rowon_n[11] net24 net23 VSS col_n[29] rowoff_n[11] col[29] adc_array_wafflecap_8_8
x383 VDD ctop vcm row_n[11] rowon_n[11] net24 net23 VSS col_n[30] rowoff_n[11] col[30] adc_array_wafflecap_8_8
x384 VDD ctop vcm row_n[11] rowon_n[11] net24 net23 VSS col_n[31] rowoff_n[11] col[31] adc_array_wafflecap_8_8
x385 VDD ctop vcm row_n[12] rowon_n[12] net26 net25 VSS col_n[0] rowoff_n[12] col[0] adc_array_wafflecap_8_8
x386 VDD ctop vcm row_n[12] rowon_n[12] net26 net25 VSS col_n[1] rowoff_n[12] col[1] adc_array_wafflecap_8_8
x387 VDD ctop vcm row_n[12] rowon_n[12] net26 net25 VSS col_n[2] rowoff_n[12] col[2] adc_array_wafflecap_8_8
x388 VDD ctop vcm row_n[12] rowon_n[12] net26 net25 VSS col_n[3] rowoff_n[12] col[3] adc_array_wafflecap_8_8
x389 VDD ctop vcm row_n[12] rowon_n[12] net26 net25 VSS col_n[4] rowoff_n[12] col[4] adc_array_wafflecap_8_8
x390 VDD ctop vcm row_n[12] rowon_n[12] net26 net25 VSS col_n[5] rowoff_n[12] col[5] adc_array_wafflecap_8_8
x391 VDD ctop vcm row_n[12] rowon_n[12] net26 net25 VSS col_n[6] rowoff_n[12] col[6] adc_array_wafflecap_8_8
x392 VDD ctop vcm row_n[12] rowon_n[12] net26 net25 VSS col_n[7] rowoff_n[12] col[7] adc_array_wafflecap_8_8
x393 VDD ctop vcm row_n[12] rowon_n[12] net26 net25 VSS col_n[8] rowoff_n[12] col[8] adc_array_wafflecap_8_8
x394 VDD ctop vcm row_n[12] rowon_n[12] net26 net25 VSS col_n[9] rowoff_n[12] col[9] adc_array_wafflecap_8_8
x395 VDD ctop vcm row_n[12] rowon_n[12] net26 net25 VSS col_n[10] rowoff_n[12] col[10] adc_array_wafflecap_8_8
x396 VDD ctop vcm row_n[12] rowon_n[12] net26 net25 VSS col_n[11] rowoff_n[12] col[11] adc_array_wafflecap_8_8
x397 VDD ctop vcm row_n[12] rowon_n[12] net26 net25 VSS col_n[12] rowoff_n[12] col[12] adc_array_wafflecap_8_8
x398 VDD ctop vcm row_n[12] rowon_n[12] net26 net25 VSS col_n[13] rowoff_n[12] col[13] adc_array_wafflecap_8_8
x399 VDD ctop vcm row_n[12] rowon_n[12] net26 net25 VSS col_n[14] rowoff_n[12] col[14] adc_array_wafflecap_8_8
x400 VDD ctop vcm row_n[12] rowon_n[12] net26 net25 VSS col_n[15] rowoff_n[12] col[15] adc_array_wafflecap_8_8
x401 VDD ctop vcm row_n[12] rowon_n[12] net26 net25 VSS col_n[16] rowoff_n[12] col[16] adc_array_wafflecap_8_8
x402 VDD ctop vcm row_n[12] rowon_n[12] net26 net25 VSS col_n[17] rowoff_n[12] col[17] adc_array_wafflecap_8_8
x403 VDD ctop vcm row_n[12] rowon_n[12] net26 net25 VSS col_n[18] rowoff_n[12] col[18] adc_array_wafflecap_8_8
x404 VDD ctop vcm row_n[12] rowon_n[12] net26 net25 VSS col_n[19] rowoff_n[12] col[19] adc_array_wafflecap_8_8
x405 VDD ctop vcm row_n[12] rowon_n[12] net26 net25 VSS col_n[20] rowoff_n[12] col[20] adc_array_wafflecap_8_8
x406 VDD ctop vcm row_n[12] rowon_n[12] net26 net25 VSS col_n[21] rowoff_n[12] col[21] adc_array_wafflecap_8_8
x407 VDD ctop vcm row_n[12] rowon_n[12] net26 net25 VSS col_n[22] rowoff_n[12] col[22] adc_array_wafflecap_8_8
x408 VDD ctop vcm row_n[12] rowon_n[12] net26 net25 VSS col_n[23] rowoff_n[12] col[23] adc_array_wafflecap_8_8
x409 VDD ctop vcm row_n[12] rowon_n[12] net26 net25 VSS col_n[24] rowoff_n[12] col[24] adc_array_wafflecap_8_8
x410 VDD ctop vcm row_n[12] rowon_n[12] net26 net25 VSS col_n[25] rowoff_n[12] col[25] adc_array_wafflecap_8_8
x411 VDD ctop vcm row_n[12] rowon_n[12] net26 net25 VSS col_n[26] rowoff_n[12] col[26] adc_array_wafflecap_8_8
x412 VDD ctop vcm row_n[12] rowon_n[12] net26 net25 VSS col_n[27] rowoff_n[12] col[27] adc_array_wafflecap_8_8
x413 VDD ctop vcm row_n[12] rowon_n[12] net26 net25 VSS col_n[28] rowoff_n[12] col[28] adc_array_wafflecap_8_8
x414 VDD ctop vcm row_n[12] rowon_n[12] net26 net25 VSS col_n[29] rowoff_n[12] col[29] adc_array_wafflecap_8_8
x415 VDD ctop vcm row_n[12] rowon_n[12] net26 net25 VSS col_n[30] rowoff_n[12] col[30] adc_array_wafflecap_8_8
x416 VDD ctop vcm row_n[12] rowon_n[12] net26 net25 VSS col_n[31] rowoff_n[12] col[31] adc_array_wafflecap_8_8
x417 VDD ctop vcm row_n[13] rowon_n[13] net28 net27 VSS col_n[0] rowoff_n[13] col[0] adc_array_wafflecap_8_8
x418 VDD ctop vcm row_n[13] rowon_n[13] net28 net27 VSS col_n[1] rowoff_n[13] col[1] adc_array_wafflecap_8_8
x419 VDD ctop vcm row_n[13] rowon_n[13] net28 net27 VSS col_n[2] rowoff_n[13] col[2] adc_array_wafflecap_8_8
x420 VDD ctop vcm row_n[13] rowon_n[13] net28 net27 VSS col_n[3] rowoff_n[13] col[3] adc_array_wafflecap_8_8
x421 VDD ctop vcm row_n[13] rowon_n[13] net28 net27 VSS col_n[4] rowoff_n[13] col[4] adc_array_wafflecap_8_8
x422 VDD ctop vcm row_n[13] rowon_n[13] net28 net27 VSS col_n[5] rowoff_n[13] col[5] adc_array_wafflecap_8_8
x423 VDD ctop vcm row_n[13] rowon_n[13] net28 net27 VSS col_n[6] rowoff_n[13] col[6] adc_array_wafflecap_8_8
x424 VDD ctop vcm row_n[13] rowon_n[13] net28 net27 VSS col_n[7] rowoff_n[13] col[7] adc_array_wafflecap_8_8
x425 VDD ctop vcm row_n[13] rowon_n[13] net28 net27 VSS col_n[8] rowoff_n[13] col[8] adc_array_wafflecap_8_8
x426 VDD ctop vcm row_n[13] rowon_n[13] net28 net27 VSS col_n[9] rowoff_n[13] col[9] adc_array_wafflecap_8_8
x427 VDD ctop vcm row_n[13] rowon_n[13] net28 net27 VSS col_n[10] rowoff_n[13] col[10] adc_array_wafflecap_8_8
x428 VDD ctop vcm row_n[13] rowon_n[13] net28 net27 VSS col_n[11] rowoff_n[13] col[11] adc_array_wafflecap_8_8
x429 VDD ctop vcm row_n[13] rowon_n[13] net28 net27 VSS col_n[12] rowoff_n[13] col[12] adc_array_wafflecap_8_8
x430 VDD ctop vcm row_n[13] rowon_n[13] net28 net27 VSS col_n[13] rowoff_n[13] col[13] adc_array_wafflecap_8_8
x431 VDD ctop vcm row_n[13] rowon_n[13] net28 net27 VSS col_n[14] rowoff_n[13] col[14] adc_array_wafflecap_8_8
x432 VDD ctop vcm row_n[13] rowon_n[13] net28 net27 VSS col_n[15] rowoff_n[13] col[15] adc_array_wafflecap_8_8
x433 VDD ctop vcm row_n[13] rowon_n[13] net28 net27 VSS col_n[16] rowoff_n[13] col[16] adc_array_wafflecap_8_8
x434 VDD ctop vcm row_n[13] rowon_n[13] net28 net27 VSS col_n[17] rowoff_n[13] col[17] adc_array_wafflecap_8_8
x435 VDD ctop vcm row_n[13] rowon_n[13] net28 net27 VSS col_n[18] rowoff_n[13] col[18] adc_array_wafflecap_8_8
x436 VDD ctop vcm row_n[13] rowon_n[13] net28 net27 VSS col_n[19] rowoff_n[13] col[19] adc_array_wafflecap_8_8
x437 VDD ctop vcm row_n[13] rowon_n[13] net28 net27 VSS col_n[20] rowoff_n[13] col[20] adc_array_wafflecap_8_8
x438 VDD ctop vcm row_n[13] rowon_n[13] net28 net27 VSS col_n[21] rowoff_n[13] col[21] adc_array_wafflecap_8_8
x439 VDD ctop vcm row_n[13] rowon_n[13] net28 net27 VSS col_n[22] rowoff_n[13] col[22] adc_array_wafflecap_8_8
x440 VDD ctop vcm row_n[13] rowon_n[13] net28 net27 VSS col_n[23] rowoff_n[13] col[23] adc_array_wafflecap_8_8
x441 VDD ctop vcm row_n[13] rowon_n[13] net28 net27 VSS col_n[24] rowoff_n[13] col[24] adc_array_wafflecap_8_8
x442 VDD ctop vcm row_n[13] rowon_n[13] net28 net27 VSS col_n[25] rowoff_n[13] col[25] adc_array_wafflecap_8_8
x443 VDD ctop vcm row_n[13] rowon_n[13] net28 net27 VSS col_n[26] rowoff_n[13] col[26] adc_array_wafflecap_8_8
x444 VDD ctop vcm row_n[13] rowon_n[13] net28 net27 VSS col_n[27] rowoff_n[13] col[27] adc_array_wafflecap_8_8
x445 VDD ctop vcm row_n[13] rowon_n[13] net28 net27 VSS col_n[28] rowoff_n[13] col[28] adc_array_wafflecap_8_8
x446 VDD ctop vcm row_n[13] rowon_n[13] net28 net27 VSS col_n[29] rowoff_n[13] col[29] adc_array_wafflecap_8_8
x447 VDD ctop vcm row_n[13] rowon_n[13] net28 net27 VSS col_n[30] rowoff_n[13] col[30] adc_array_wafflecap_8_8
x448 VDD ctop vcm row_n[13] rowon_n[13] net28 net27 VSS col_n[31] rowoff_n[13] col[31] adc_array_wafflecap_8_8
x449 VDD ctop vcm row_n[14] rowon_n[14] net30 net29 VSS col_n[0] rowoff_n[14] col[0] adc_array_wafflecap_8_8
x450 VDD ctop vcm row_n[14] rowon_n[14] net30 net29 VSS col_n[1] rowoff_n[14] col[1] adc_array_wafflecap_8_8
x451 VDD ctop vcm row_n[14] rowon_n[14] net30 net29 VSS col_n[2] rowoff_n[14] col[2] adc_array_wafflecap_8_8
x452 VDD ctop vcm row_n[14] rowon_n[14] net30 net29 VSS col_n[3] rowoff_n[14] col[3] adc_array_wafflecap_8_8
x453 VDD ctop vcm row_n[14] rowon_n[14] net30 net29 VSS col_n[4] rowoff_n[14] col[4] adc_array_wafflecap_8_8
x454 VDD ctop vcm row_n[14] rowon_n[14] net30 net29 VSS col_n[5] rowoff_n[14] col[5] adc_array_wafflecap_8_8
x455 VDD ctop vcm row_n[14] rowon_n[14] net30 net29 VSS col_n[6] rowoff_n[14] col[6] adc_array_wafflecap_8_8
x456 VDD ctop vcm row_n[14] rowon_n[14] net30 net29 VSS col_n[7] rowoff_n[14] col[7] adc_array_wafflecap_8_8
x457 VDD ctop vcm row_n[14] rowon_n[14] net30 net29 VSS col_n[8] rowoff_n[14] col[8] adc_array_wafflecap_8_8
x458 VDD ctop vcm row_n[14] rowon_n[14] net30 net29 VSS col_n[9] rowoff_n[14] col[9] adc_array_wafflecap_8_8
x459 VDD ctop vcm row_n[14] rowon_n[14] net30 net29 VSS col_n[10] rowoff_n[14] col[10] adc_array_wafflecap_8_8
x460 VDD ctop vcm row_n[14] rowon_n[14] net30 net29 VSS col_n[11] rowoff_n[14] col[11] adc_array_wafflecap_8_8
x461 VDD ctop vcm row_n[14] rowon_n[14] net30 net29 VSS col_n[12] rowoff_n[14] col[12] adc_array_wafflecap_8_8
x462 VDD ctop vcm row_n[14] rowon_n[14] net30 net29 VSS col_n[13] rowoff_n[14] col[13] adc_array_wafflecap_8_8
x463 VDD ctop vcm row_n[14] rowon_n[14] net30 net29 VSS col_n[14] rowoff_n[14] col[14] adc_array_wafflecap_8_8
x464 VDD ctop vcm row_n[14] rowon_n[14] net30 net29 VSS col_n[15] rowoff_n[14] col[15] adc_array_wafflecap_8_8
x465 VDD ctop vcm row_n[14] rowon_n[14] net30 net29 VSS col_n[16] rowoff_n[14] col[16] adc_array_wafflecap_8_8
x466 VDD ctop vcm row_n[14] rowon_n[14] net30 net29 VSS col_n[17] rowoff_n[14] col[17] adc_array_wafflecap_8_8
x467 VDD ctop vcm row_n[14] rowon_n[14] net30 net29 VSS col_n[18] rowoff_n[14] col[18] adc_array_wafflecap_8_8
x468 VDD ctop vcm row_n[14] rowon_n[14] net30 net29 VSS col_n[19] rowoff_n[14] col[19] adc_array_wafflecap_8_8
x469 VDD ctop vcm row_n[14] rowon_n[14] net30 net29 VSS col_n[20] rowoff_n[14] col[20] adc_array_wafflecap_8_8
x470 VDD ctop vcm row_n[14] rowon_n[14] net30 net29 VSS col_n[21] rowoff_n[14] col[21] adc_array_wafflecap_8_8
x471 VDD ctop vcm row_n[14] rowon_n[14] net30 net29 VSS col_n[22] rowoff_n[14] col[22] adc_array_wafflecap_8_8
x472 VDD ctop vcm row_n[14] rowon_n[14] net30 net29 VSS col_n[23] rowoff_n[14] col[23] adc_array_wafflecap_8_8
x473 VDD ctop vcm row_n[14] rowon_n[14] net30 net29 VSS col_n[24] rowoff_n[14] col[24] adc_array_wafflecap_8_8
x474 VDD ctop vcm row_n[14] rowon_n[14] net30 net29 VSS col_n[25] rowoff_n[14] col[25] adc_array_wafflecap_8_8
x475 VDD ctop vcm row_n[14] rowon_n[14] net30 net29 VSS col_n[26] rowoff_n[14] col[26] adc_array_wafflecap_8_8
x476 VDD ctop vcm row_n[14] rowon_n[14] net30 net29 VSS col_n[27] rowoff_n[14] col[27] adc_array_wafflecap_8_8
x477 VDD ctop vcm row_n[14] rowon_n[14] net30 net29 VSS col_n[28] rowoff_n[14] col[28] adc_array_wafflecap_8_8
x478 VDD ctop vcm row_n[14] rowon_n[14] net30 net29 VSS col_n[29] rowoff_n[14] col[29] adc_array_wafflecap_8_8
x479 VDD ctop vcm row_n[14] rowon_n[14] net30 net29 VSS col_n[30] rowoff_n[14] col[30] adc_array_wafflecap_8_8
x480 VDD ctop vcm row_n[14] rowon_n[14] net30 net29 VSS col_n[31] rowoff_n[14] col[31] adc_array_wafflecap_8_8
x481 VDD ctop vcm row_n[15] rowon_n[15] net32 net31 VSS col_n[0] rowoff_n[15] col[0] adc_array_wafflecap_8_8
x482 VDD ctop vcm row_n[15] rowon_n[15] net32 net31 VSS col_n[1] rowoff_n[15] col[1] adc_array_wafflecap_8_8
x483 VDD ctop vcm row_n[15] rowon_n[15] net32 net31 VSS col_n[2] rowoff_n[15] col[2] adc_array_wafflecap_8_8
x484 VDD ctop vcm row_n[15] rowon_n[15] net32 net31 VSS col_n[3] rowoff_n[15] col[3] adc_array_wafflecap_8_8
x485 VDD ctop vcm row_n[15] rowon_n[15] net32 net31 VSS col_n[4] rowoff_n[15] col[4] adc_array_wafflecap_8_8
x486 VDD ctop vcm row_n[15] rowon_n[15] net32 net31 VSS col_n[5] rowoff_n[15] col[5] adc_array_wafflecap_8_8
x487 VDD ctop vcm row_n[15] rowon_n[15] net32 net31 VSS col_n[6] rowoff_n[15] col[6] adc_array_wafflecap_8_8
x488 VDD ctop vcm row_n[15] rowon_n[15] net32 net31 VSS col_n[7] rowoff_n[15] col[7] adc_array_wafflecap_8_8
x489 VDD ctop vcm row_n[15] rowon_n[15] net32 net31 VSS col_n[8] rowoff_n[15] col[8] adc_array_wafflecap_8_8
x490 VDD ctop vcm row_n[15] rowon_n[15] net32 net31 VSS col_n[9] rowoff_n[15] col[9] adc_array_wafflecap_8_8
x491 VDD ctop vcm row_n[15] rowon_n[15] net32 net31 VSS col_n[10] rowoff_n[15] col[10] adc_array_wafflecap_8_8
x492 VDD ctop vcm row_n[15] rowon_n[15] net32 net31 VSS col_n[11] rowoff_n[15] col[11] adc_array_wafflecap_8_8
x493 VDD ctop vcm row_n[15] rowon_n[15] net32 net31 VSS col_n[12] rowoff_n[15] col[12] adc_array_wafflecap_8_8
x494 VDD ctop vcm row_n[15] rowon_n[15] net32 net31 VSS col_n[13] rowoff_n[15] col[13] adc_array_wafflecap_8_8
x495 VDD ctop vcm row_n[15] rowon_n[15] net32 net31 VSS col_n[14] rowoff_n[15] col[14] adc_array_wafflecap_8_8
x496 VDD ctop vcm row_n[15] rowon_n[15] net32 net31 VSS col_n[15] rowoff_n[15] col[15] adc_array_wafflecap_8_8
x497 VDD ctop vcm row_n[15] rowon_n[15] net32 net31 VSS col_n[16] rowoff_n[15] col[16] adc_array_wafflecap_8_8
x498 VDD ctop vcm row_n[15] rowon_n[15] net32 net31 VSS col_n[17] rowoff_n[15] col[17] adc_array_wafflecap_8_8
x499 VDD ctop vcm row_n[15] rowon_n[15] net32 net31 VSS col_n[18] rowoff_n[15] col[18] adc_array_wafflecap_8_8
x500 VDD ctop vcm row_n[15] rowon_n[15] net32 net31 VSS col_n[19] rowoff_n[15] col[19] adc_array_wafflecap_8_8
x501 VDD ctop vcm row_n[15] rowon_n[15] net32 net31 VSS col_n[20] rowoff_n[15] col[20] adc_array_wafflecap_8_8
x502 VDD ctop vcm row_n[15] rowon_n[15] net32 net31 VSS col_n[21] rowoff_n[15] col[21] adc_array_wafflecap_8_8
x503 VDD ctop vcm row_n[15] rowon_n[15] net32 net31 VSS col_n[22] rowoff_n[15] col[22] adc_array_wafflecap_8_8
x504 VDD ctop vcm row_n[15] rowon_n[15] net32 net31 VSS col_n[23] rowoff_n[15] col[23] adc_array_wafflecap_8_8
x505 VDD ctop vcm row_n[15] rowon_n[15] net32 net31 VSS col_n[24] rowoff_n[15] col[24] adc_array_wafflecap_8_8
x506 VDD ctop vcm row_n[15] rowon_n[15] net32 net31 VSS col_n[25] rowoff_n[15] col[25] adc_array_wafflecap_8_8
x507 VDD ctop vcm row_n[15] rowon_n[15] net32 net31 VSS col_n[26] rowoff_n[15] col[26] adc_array_wafflecap_8_8
x508 VDD ctop vcm row_n[15] rowon_n[15] net32 net31 VSS col_n[27] rowoff_n[15] col[27] adc_array_wafflecap_8_8
x509 VDD ctop vcm row_n[15] rowon_n[15] net32 net31 VSS col_n[28] rowoff_n[15] col[28] adc_array_wafflecap_8_8
x510 VDD ctop vcm row_n[15] rowon_n[15] net32 net31 VSS col_n[29] rowoff_n[15] col[29] adc_array_wafflecap_8_8
x511 VDD ctop vcm row_n[15] rowon_n[15] net32 net31 VSS col_n[30] rowoff_n[15] col[30] adc_array_wafflecap_8_8
x512 VDD ctop vcm row_n[15] rowon_n[15] net32 net31 VSS col_n[31] rowoff_n[15] col[31] adc_array_wafflecap_8_8
x1025 VDD ctop vcm row_n[0] rowon_n[0] sample_n sample VSS VDD net2 net1 rowoff_n[0] VSS adc_array_wafflecap_8_drv
x1026 VDD ctop vcm row_n[1] rowon_n[1] sample_n sample VSS VDD net4 net3 rowoff_n[1] VSS adc_array_wafflecap_8_drv
x1027 VDD ctop vcm row_n[2] rowon_n[2] sample_n sample VSS VDD net6 net5 rowoff_n[2] VSS adc_array_wafflecap_8_drv
x1028 VDD ctop vcm row_n[3] rowon_n[3] sample_n sample VSS VDD net8 net7 rowoff_n[3] VSS adc_array_wafflecap_8_drv
x1029 VDD ctop vcm row_n[4] rowon_n[4] sample_n sample VSS VDD net10 net9 rowoff_n[4] VSS adc_array_wafflecap_8_drv
x1030 VDD ctop vcm row_n[5] rowon_n[5] sample_n sample VSS VDD net12 net11 rowoff_n[5] VSS adc_array_wafflecap_8_drv
x1031 VDD ctop vcm row_n[6] rowon_n[6] sample_n sample VSS VDD net14 net13 rowoff_n[6] VSS adc_array_wafflecap_8_drv
x1032 VDD ctop vcm row_n[7] rowon_n[7] sample_n sample VSS VDD net16 net15 rowoff_n[7] VSS adc_array_wafflecap_8_drv
x1033 VDD ctop vcm row_n[8] rowon_n[8] sample_n sample VSS VDD net18 net17 rowoff_n[8] VSS adc_array_wafflecap_8_drv
x1034 VDD ctop vcm row_n[9] rowon_n[9] sample_n sample VSS VDD net20 net19 rowoff_n[9] VSS adc_array_wafflecap_8_drv
x1035 VDD ctop vcm row_n[10] rowon_n[10] sample_n sample VSS VDD net22 net21 rowoff_n[10] VSS adc_array_wafflecap_8_drv
x1036 VDD ctop vcm row_n[11] rowon_n[11] sample_n sample VSS VDD net24 net23 rowoff_n[11] VSS adc_array_wafflecap_8_drv
x1037 VDD ctop vcm row_n[12] rowon_n[12] sample_n sample VSS VDD net26 net25 rowoff_n[12] VSS adc_array_wafflecap_8_drv
x1038 VDD ctop vcm row_n[13] rowon_n[13] sample_n sample VSS VDD net28 net27 rowoff_n[13] VSS adc_array_wafflecap_8_drv
x1039 VDD ctop vcm row_n[14] rowon_n[14] sample_n sample VSS VDD net30 net29 rowoff_n[14] VSS adc_array_wafflecap_8_drv
x1040 VDD ctop vcm row_n[15] rowon_n[15] sample_n sample VSS VDD net32 net31 rowoff_n[15] VSS adc_array_wafflecap_8_drv
x1058 VDD ctop vcm VDD VSS net33 net34 VSS col_n[0] col[0] VDD adc_array_wafflecap_8_dummy
x1061 VDD ctop vcm VDD VSS net33 net34 VSS col_n[3] col[3] VDD adc_array_wafflecap_8_dummy
x1062 VDD ctop vcm VDD VSS net33 net34 VSS col_n[4] col[4] VDD adc_array_wafflecap_8_dummy
x1063 VDD ctop vcm VDD VSS net33 net34 VSS col_n[5] col[5] VDD adc_array_wafflecap_8_dummy
x1064 VDD ctop vcm VDD VSS net33 net34 VSS col_n[6] col[6] VDD adc_array_wafflecap_8_dummy
x1065 VDD ctop vcm VDD VSS net33 net34 VSS col_n[7] col[7] VDD adc_array_wafflecap_8_dummy
x1067 VDD ctop vcm VDD VSS net33 net34 VSS col_n[9] col[9] VDD adc_array_wafflecap_8_dummy
x1069 VDD ctop vcm VDD VSS net33 net34 VSS col_n[11] col[11] VDD adc_array_wafflecap_8_dummy
x1071 VDD ctop vcm VDD VSS net33 net34 VSS col_n[13] col[13] VDD adc_array_wafflecap_8_dummy
x1072 VDD ctop vcm VDD VSS net33 net34 VSS col_n[14] col[14] VDD adc_array_wafflecap_8_dummy
x1073 VDD ctop vcm VDD VSS net33 net34 VSS col_n[8] col[8] VDD adc_array_wafflecap_8_dummy
x1075 VDD ctop vcm VDD VSS net33 net34 VSS col_n[24] col[24] VDD adc_array_wafflecap_8_dummy
x1077 VDD ctop vcm VDD VSS net33 net34 VSS col_n[19] col[19] VDD adc_array_wafflecap_8_dummy
x1078 VDD ctop vcm VDD VSS net33 net34 VSS col_n[20] col[20] VDD adc_array_wafflecap_8_dummy
x1079 VDD ctop vcm VDD VSS net33 net34 VSS col_n[21] col[21] VDD adc_array_wafflecap_8_dummy
x1080 VDD ctop vcm VDD VSS net33 net34 VSS col_n[22] col[22] VDD adc_array_wafflecap_8_dummy
x1081 VDD ctop vcm VDD VSS net33 net34 VSS col_n[23] col[23] VDD adc_array_wafflecap_8_dummy
x1083 VDD ctop vcm VDD VSS net33 net34 VSS col_n[25] col[25] VDD adc_array_wafflecap_8_dummy
x1085 VDD ctop vcm VDD VSS net33 net34 VSS col_n[12] col[12] VDD adc_array_wafflecap_8_dummy
x1086 VDD ctop vcm VDD VSS net33 net34 VSS col_n[28] col[28] VDD adc_array_wafflecap_8_dummy
x1087 VDD ctop vcm VDD VSS net33 net34 VSS col_n[29] col[29] VDD adc_array_wafflecap_8_dummy
x1088 VDD ctop vcm VDD VSS net33 net34 VSS col_n[30] col[30] VDD adc_array_wafflecap_8_dummy
x1089 VDD ctop vcm VDD VSS net33 net34 VSS col_n[27] col[27] VDD adc_array_wafflecap_8_dummy
x1090 VDD ctop vcm VDD VSS net33 net34 VSS VDD VSS VDD adc_array_wafflecap_8_dummy
x1092 VDD ctop vcm VDD VDD net35 net36 VSS col_n[0] col[0] VSS adc_array_wafflecap_8_dummy
x1093 VDD ctop vcm VDD VDD net35 net36 VSS col_n[1] col[1] VSS adc_array_wafflecap_8_dummy
x1094 VDD ctop vcm VDD VDD net35 net36 VSS col_n[2] col[2] VSS adc_array_wafflecap_8_dummy
x1095 VDD ctop vcm VDD VDD net35 net36 VSS col_n[3] col[3] VSS adc_array_wafflecap_8_dummy
x1096 VDD ctop vcm VDD VDD net35 net36 VSS col_n[4] col[4] VSS adc_array_wafflecap_8_dummy
x1097 VDD ctop vcm VDD VDD net35 net36 VSS col_n[5] col[5] VSS adc_array_wafflecap_8_dummy
x1098 VDD ctop vcm VDD VDD net35 net36 VSS col_n[6] col[6] VSS adc_array_wafflecap_8_dummy
x1099 VDD ctop vcm VDD VDD net35 net36 VSS col_n[7] col[7] VSS adc_array_wafflecap_8_dummy
x1100 VDD ctop vcm VDD VDD net35 net36 VSS col_n[8] col[8] VSS adc_array_wafflecap_8_dummy
x1101 VDD ctop vcm VDD VDD net35 net36 VSS col_n[9] col[9] VSS adc_array_wafflecap_8_dummy
x1102 VDD ctop vcm VDD VDD net35 net36 VSS col_n[10] col[10] VSS adc_array_wafflecap_8_dummy
x1103 VDD ctop vcm VDD VDD net35 net36 VSS col_n[11] col[11] VSS adc_array_wafflecap_8_dummy
x1104 VDD ctop vcm VDD VDD net35 net36 VSS col_n[12] col[12] VSS adc_array_wafflecap_8_dummy
x1105 VDD ctop vcm VDD VDD net35 net36 VSS col_n[13] col[13] VSS adc_array_wafflecap_8_dummy
x1106 VDD ctop vcm VDD VDD net35 net36 VSS col_n[14] col[14] VSS adc_array_wafflecap_8_dummy
x1107 VDD ctop vcm VDD VDD net35 net36 VSS col_n[15] col[15] VSS adc_array_wafflecap_8_dummy
x1108 VDD ctop vcm VDD VDD net35 net36 VSS col_n[16] col[16] VSS adc_array_wafflecap_8_dummy
x1109 VDD ctop vcm VDD VDD net35 net36 VSS col_n[17] col[17] VSS adc_array_wafflecap_8_dummy
x1110 VDD ctop vcm VDD VDD net35 net36 VSS col_n[18] col[18] VSS adc_array_wafflecap_8_dummy
x1111 VDD ctop vcm VDD VDD net35 net36 VSS col_n[19] col[19] VSS adc_array_wafflecap_8_dummy
x1112 VDD ctop vcm VDD VDD net35 net36 VSS col_n[20] col[20] VSS adc_array_wafflecap_8_dummy
x1113 VDD ctop vcm VDD VDD net35 net36 VSS col_n[21] col[21] VSS adc_array_wafflecap_8_dummy
x1114 VDD ctop vcm VDD VDD net35 net36 VSS col_n[22] col[22] VSS adc_array_wafflecap_8_dummy
x1115 VDD ctop vcm VDD VDD net35 net36 VSS col_n[23] col[23] VSS adc_array_wafflecap_8_dummy
x1116 VDD ctop vcm VDD VDD net35 net36 VSS col_n[24] col[24] VSS adc_array_wafflecap_8_dummy
x1117 VDD ctop vcm VDD VDD net35 net36 VSS col_n[25] col[25] VSS adc_array_wafflecap_8_dummy
x1118 VDD ctop vcm VDD VDD net35 net36 VSS col_n[26] col[26] VSS adc_array_wafflecap_8_dummy
x1119 VDD ctop vcm VDD VDD net35 net36 VSS col_n[27] col[27] VSS adc_array_wafflecap_8_dummy
x1120 VDD ctop vcm VDD VDD net35 net36 VSS col_n[28] col[28] VSS adc_array_wafflecap_8_dummy
x1121 VDD ctop vcm VDD VDD net35 net36 VSS col_n[29] col[29] VSS adc_array_wafflecap_8_dummy
x1122 VDD ctop vcm VDD VDD net35 net36 VSS col_n[30] col[30] VSS adc_array_wafflecap_8_dummy
x1123 VDD ctop vcm VDD VDD net35 net36 VSS col_n[31] col[31] VSS adc_array_wafflecap_8_dummy
x1124 VDD ctop vcm VDD VDD net35 net36 VSS VDD VSS VSS adc_array_wafflecap_8_dummy
x1125 VDD ctop vcm row_n[0] rowon_n[0] net2 net1 VSS VDD VSS rowoff_n[0] adc_array_wafflecap_8_dummy
x1126 VDD ctop vcm row_n[1] rowon_n[1] net4 net3 VSS VDD VSS rowoff_n[1] adc_array_wafflecap_8_dummy
x1127 VDD ctop vcm row_n[2] rowon_n[2] net6 net5 VSS VDD VSS rowoff_n[2] adc_array_wafflecap_8_dummy
x1128 VDD ctop vcm row_n[3] rowon_n[3] net8 net7 VSS VDD VSS rowoff_n[3] adc_array_wafflecap_8_dummy
x1129 VDD ctop vcm row_n[4] rowon_n[4] net10 net9 VSS VDD VSS rowoff_n[4] adc_array_wafflecap_8_dummy
x1130 VDD ctop vcm row_n[5] rowon_n[5] net12 net11 VSS VDD VSS rowoff_n[5] adc_array_wafflecap_8_dummy
x1131 VDD ctop vcm row_n[6] rowon_n[6] net14 net13 VSS VDD VSS rowoff_n[6] adc_array_wafflecap_8_dummy
x1132 VDD ctop vcm row_n[7] rowon_n[7] net16 net15 VSS VDD VSS rowoff_n[7] adc_array_wafflecap_8_dummy
x1133 VDD ctop vcm row_n[8] rowon_n[8] net18 net17 VSS VDD VSS rowoff_n[8] adc_array_wafflecap_8_dummy
x1134 VDD ctop vcm row_n[9] rowon_n[9] net20 net19 VSS VDD VSS rowoff_n[9] adc_array_wafflecap_8_dummy
x1135 VDD ctop vcm row_n[10] rowon_n[10] net22 net21 VSS VDD VSS rowoff_n[10] adc_array_wafflecap_8_dummy
x1136 VDD ctop vcm row_n[11] rowon_n[11] net24 net23 VSS VDD VSS rowoff_n[11] adc_array_wafflecap_8_dummy
x1137 VDD ctop vcm row_n[12] rowon_n[12] net26 net25 VSS VDD VSS rowoff_n[12] adc_array_wafflecap_8_dummy
x1138 VDD ctop vcm row_n[13] rowon_n[13] net28 net27 VSS VDD VSS rowoff_n[13] adc_array_wafflecap_8_dummy
x1139 VDD ctop vcm row_n[14] rowon_n[14] net30 net29 VSS VDD VSS rowoff_n[14] adc_array_wafflecap_8_dummy
x1140 VDD ctop vcm row_n[15] rowon_n[15] net32 net31 VSS VDD VSS rowoff_n[15] adc_array_wafflecap_8_dummy
x513 VDD ctop vcm VDD VSS net33 net34 VSS col_n[2] col[2] VDD adc_array_wafflecap_8_dummy
x514 VDD ctop vcm VDD VSS net33 net34 VSS col_n[10] col[10] VDD adc_array_wafflecap_8_dummy
x515 VDD ctop vcm VDD VSS net33 net34 VSS col_n[18] col[18] VDD adc_array_wafflecap_8_dummy
x516 VDD ctop vcm VDD VSS net33 net34 VSS col_n[26] col[26] VDD adc_array_wafflecap_8_dummy
x517 VDD ctop vcm VDD VSS net33 net34 VSS col_n[16] en_bit_n[2] VDD col[16] adc_array_wafflecap_8_4
x518 VDD ctop vcm VDD VSS net33 net34 VSS col_n[15] en_bit_n[1] VDD col[15] adc_array_wafflecap_8_2
x519 VDD ctop vcm VDD VSS net33 net34 VSS col_n[17] en_bit_n[0] VDD col[17] adc_array_wafflecap_8_1
x520 VDD ctop vcm VDD VSS net33 net34 VSS col_n[31] sw analog_in sw_n col[31] VDD adc_array_wafflecap_8_gate
x14 VDD ctop vcm row_n[0] rowon_n[0] net2 net1 VSS col_n[13] rowoff_n[0] col[13] adc_array_wafflecap_8_8
x5211 VDD VSS VDD VSS VSS adc_noise_decoup_cell1
x5212 VDD VSS VDD VSS VSS adc_noise_decoup_cell1
x5213 VDD VSS VDD VSS VSS adc_noise_decoup_cell1
x5214 VDD VSS VDD VSS VSS adc_noise_decoup_cell1
x5215 VDD VSS VDD VSS VSS adc_noise_decoup_cell1
x5216 VDD VSS VDD VSS VSS adc_noise_decoup_cell1
x5217 VDD VSS VDD VSS VSS adc_noise_decoup_cell1
x5218 VDD VSS VDD VSS VSS adc_noise_decoup_cell1
x5219 VDD VSS VDD VSS VSS adc_noise_decoup_cell1
x52110 VDD VSS VDD VSS VSS adc_noise_decoup_cell1
x52111 VDD VSS VDD VSS VSS adc_noise_decoup_cell1
x52112 VDD VSS VDD VSS VSS adc_noise_decoup_cell1
x52113 VDD VSS VDD VSS VSS adc_noise_decoup_cell1
x52114 VDD VSS VDD VSS VSS adc_noise_decoup_cell1
x52115 VDD VSS VDD VSS VSS adc_noise_decoup_cell1
x1 VDD ctop vcm row_n[0] rowon_n[0] net2 net1 VSS col_n[0] col[0] rowoff_n[0] adc_array_wafflecap_8_dummy
x521 VDD ctop vcm VDD VSS net33 net34 VSS col_n[1] en_C0_n VDD col[1] adc_array_wafflecap_8_1
x522 VDD ctop vcm VDD VSS sample_n sample VSS VDD net33 net34 VDD VSS adc_array_wafflecap_8_drv
x523 VDD ctop vcm VDD VDD sample_n sample VSS VDD net35 net36 VSS VSS adc_array_wafflecap_8_drv
.ends

* expanding   symbol:  adc_comp_latch.sym # of pins=8
** sym_path: /home/agrancagnolo/Prueba_PI_Lore/SoC_for_CubeSat/xschem/adc_comp_latch.sym
** sch_path: /home/agrancagnolo/Prueba_PI_Lore/SoC_for_CubeSat/xschem/adc_comp_latch.sch
.subckt adc_comp_latch VDD VSS clk inp inn comp_trig latch_qn latch_q
*.iopin VDD
*.iopin VSS
*.ipin clk
*.ipin inp
*.ipin inn
*.opin comp_trig
*.opin latch_qn
*.opin latch_q
x4 VDD VSS clk net1 adc_inverter
x5 VDD VSS net1 net2 adc_inverter
x1 VDD VSS net2 net1 inp inn comp_outp comp_outn adc_comp_circuit
x3 comp_outp comp_outn VDD comp_trig VSS adc_nor
x2 comp_outp latch_qn VDD latch_q VSS comp_outn adc_nor_latch
.ends

* expanding   symbol:  adc_array_wafflecap_8_8.sym # of pins=11
** sym_path: /home/agrancagnolo/Prueba_PI_Lore/SoC_for_CubeSat/xschem/adc_array_wafflecap_8_8.sym
** sch_path: /home/agrancagnolo/Prueba_PI_Lore/SoC_for_CubeSat/xschem/adc_array_wafflecap_8_8.sch
.subckt adc_array_wafflecap_8_8 VDD ctop vcom row_n rowon_n sample_n sample VSS col_n rowoff_n col
*.iopin vcom
*.iopin VDD
*.iopin ctop
*.iopin VSS
*.ipin row_n
*.ipin col_n
*.ipin rowon_n
*.ipin sample_n
*.ipin sample
*.ipin rowoff_n
*.ipin col
C1 ctop cbot 2.90f
x1 VDD col_n cbot row_n rowon_n sample_n vcom sample VSS rowoff_n col adc_array_circuit_8
.ends

* expanding   symbol:  adc_array_wafflecap_8_drv.sym # of pins=13
** sym_path: /home/agrancagnolo/Prueba_PI_Lore/SoC_for_CubeSat/xschem/adc_array_wafflecap_8_drv.sym
** sch_path: /home/agrancagnolo/Prueba_PI_Lore/SoC_for_CubeSat/xschem/adc_array_wafflecap_8_drv.sch
.subckt adc_array_wafflecap_8_drv VDD ctop vcom row_n rowon_n sample_n_i sample_i VSS col_n sample_n_o sample_o rowoff_n col
*.ipin sample_n_i
*.ipin sample_i
*.iopin vcom
*.iopin VDD
*.iopin ctop
*.iopin VSS
*.opin sample_n_o
*.opin sample_o
*.ipin row_n
*.ipin col_n
*.ipin rowon_n
*.ipin rowoff_n
*.ipin col
x1 VDD col_n row_n rowon_n sample_n_i vcom sample_i VSS sample_n_o sample_o rowoff_n col adc_array_circuit_drv
* noconn ctop
.ends

* expanding   symbol:  adc_array_wafflecap_8_dummy.sym # of pins=11
** sym_path: /home/agrancagnolo/Prueba_PI_Lore/SoC_for_CubeSat/xschem/adc_array_wafflecap_8_dummy.sym
** sch_path: /home/agrancagnolo/Prueba_PI_Lore/SoC_for_CubeSat/xschem/adc_array_wafflecap_8_dummy.sch
.subckt adc_array_wafflecap_8_dummy VDD ctop vcom row_n rowon_n sample_n sample VSS col_n col rowoff_n
*.iopin vcom
*.iopin VDD
*.iopin ctop
*.iopin VSS
*.ipin row_n
*.ipin col_n
*.ipin rowon_n
*.ipin sample_n
*.ipin sample
*.ipin rowoff_n
*.ipin col
* noconn ctop
x1 VDD col_n cbot row_n rowon_n sample_n vcom sample VSS rowoff_n col adc_array_circuit_8
.ends

* expanding   symbol:  adc_array_wafflecap_8_4.sym # of pins=12
** sym_path: /home/agrancagnolo/Prueba_PI_Lore/SoC_for_CubeSat/xschem/adc_array_wafflecap_8_4.sym
** sch_path: /home/agrancagnolo/Prueba_PI_Lore/SoC_for_CubeSat/xschem/adc_array_wafflecap_8_4.sch
.subckt adc_array_wafflecap_8_4 VDD ctop vcom row_n rowon_n sample_n sample VSS col_n en_n rowoff_n col
*.iopin vcom
*.iopin VDD
*.iopin ctop
*.iopin VSS
*.ipin en_n
*.ipin row_n
*.ipin col_n
*.ipin rowon_n
*.ipin sample_n
*.ipin sample
*.ipin rowoff_n
*.ipin col
C3 ctop cbot 1.46f
x1 VDD col_n cbot row_n rowon_n sample_n vcom sample VSS en_n rowoff_n col adc_array_circuit_4
.ends

* expanding   symbol:  adc_array_wafflecap_8_2.sym # of pins=12
** sym_path: /home/agrancagnolo/Prueba_PI_Lore/SoC_for_CubeSat/xschem/adc_array_wafflecap_8_2.sym
** sch_path: /home/agrancagnolo/Prueba_PI_Lore/SoC_for_CubeSat/xschem/adc_array_wafflecap_8_2.sch
.subckt adc_array_wafflecap_8_2 VDD ctop vcom row_n rowon_n sample_n sample VSS col_n en_n rowoff_n col
*.iopin vcom
*.iopin VDD
*.iopin ctop
*.iopin VSS
*.ipin en_n
*.ipin row_n
*.ipin col_n
*.ipin rowon_n
*.ipin sample_n
*.ipin sample
*.ipin col
*.ipin rowoff_n
C3 ctop cbot 0.72f
x1 VDD col_n cbot row_n rowon_n sample_n vcom sample VSS en_n rowoff_n col adc_array_circuit_2
.ends

* expanding   symbol:  adc_array_wafflecap_8_1.sym # of pins=12
** sym_path: /home/agrancagnolo/Prueba_PI_Lore/SoC_for_CubeSat/xschem/adc_array_wafflecap_8_1.sym
** sch_path: /home/agrancagnolo/Prueba_PI_Lore/SoC_for_CubeSat/xschem/adc_array_wafflecap_8_1.sch
.subckt adc_array_wafflecap_8_1 VDD ctop vcom row_n rowon_n sample_n sample VSS col_n en_n rowoff_n col
*.iopin vcom
*.iopin VDD
*.iopin ctop
*.iopin VSS
*.ipin en_n
*.ipin row_n
*.ipin col_n
*.ipin rowon_n
*.ipin sample_n
*.ipin sample
*.ipin rowoff_n
*.ipin col
C3 ctop cbot 0.36f
x1 VDD col_n cbot row_n rowon_n sample_n vcom sample VSS en_n rowoff_n col adc_array_circuit_1
.ends

* expanding   symbol:  adc_array_wafflecap_8_gate.sym # of pins=14
** sym_path: /home/agrancagnolo/Prueba_PI_Lore/SoC_for_CubeSat/xschem/adc_array_wafflecap_8_gate.sym
** sch_path: /home/agrancagnolo/Prueba_PI_Lore/SoC_for_CubeSat/xschem/adc_array_wafflecap_8_gate.sch
.subckt adc_array_wafflecap_8_gate VDD ctop vcom row_n rowon_n sample_n sample VSS col_n sw in sw_n col rowoff_n
*.iopin vcom
*.iopin VDD
*.iopin ctop
*.iopin VSS
*.ipin row_n
*.ipin col_n
*.ipin rowon_n
*.ipin sample_n
*.ipin sample
*.iopin in
*.ipin sw
*.ipin sw_n
*.ipin rowoff_n
*.ipin col
x1 VDD col_n row_n rowon_n sample_n vcom sample VSS ctop in sw_n sw rowoff_n col adc_array_circuit_gate
.ends

* expanding   symbol:  adc_noise_decoup_cell1.sym # of pins=5
** sym_path: /home/agrancagnolo/Prueba_PI_Lore/SoC_for_CubeSat/xschem/adc_noise_decoup_cell1.sym
** sch_path: /home/agrancagnolo/Prueba_PI_Lore/SoC_for_CubeSat/xschem/adc_noise_decoup_cell1.sch
.subckt adc_noise_decoup_cell1 mimcap_top mimcap_bot nmoscap_top nmoscap_bot pwell
*.iopin nmoscap_top
*.iopin mimcap_top
*.iopin mimcap_bot
*.iopin nmoscap_bot
*.iopin pwell
XC1 mimcap_top mimcap_bot sky130_fd_pr__cap_mim_m3_1 W=17.2 L=17.2 MF=1
XC2 nmoscap_top nmoscap_bot pwell sky130_fd_pr__cap_var_lvt W=16.4 L=16.0 VM=1
.ends

* expanding   symbol:  adc_inverter.sym # of pins=4
** sym_path: /home/agrancagnolo/Prueba_PI_Lore/SoC_for_CubeSat/xschem/adc_inverter.sym
** sch_path: /home/agrancagnolo/Prueba_PI_Lore/SoC_for_CubeSat/xschem/adc_inverter.sch
.subckt adc_inverter VDD VSS in out
*.iopin VDD
*.iopin VSS
*.ipin in
*.opin out
XM2 out in VDD VDD sky130_fd_pr__pfet_01v8 L=0.15 W=0.84 nf=2 ad='int((nf+1)/2) * W/nf * 0.29' as='int((nf+2)/2) * W/nf * 0.29' pd='2*int((nf+1)/2) * (W/nf + 0.29)'
+ ps='2*int((nf+2)/2) * (W/nf + 0.29)' nrd='0.29 / W' nrs='0.29 / W' sa=0 sb=0 sd=0 mult=1
XM1 out in VSS VSS sky130_fd_pr__nfet_01v8 L=0.15 W=0.42 nf=1 ad='int((nf+1)/2) * W/nf * 0.29' as='int((nf+2)/2) * W/nf * 0.29' pd='2*int((nf+1)/2) * (W/nf + 0.29)'
+ ps='2*int((nf+2)/2) * (W/nf + 0.29)' nrd='0.29 / W' nrs='0.29 / W' sa=0 sb=0 sd=0 mult=1
.ends

* expanding   symbol:  adc_comp_circuit.sym # of pins=8
** sym_path: /home/agrancagnolo/Prueba_PI_Lore/SoC_for_CubeSat/xschem/adc_comp_circuit.sym
** sch_path: /home/agrancagnolo/Prueba_PI_Lore/SoC_for_CubeSat/xschem/adc_comp_circuit.sch
.subckt adc_comp_circuit VPWR VGND clk nclk inp inn outp outn
*.iopin VPWR
*.iopin VGND
*.ipin clk
*.ipin nclk
*.ipin inp
*.ipin inn
*.opin outp
*.opin outn
XM3 on inp in_stage_net1 VGND sky130_fd_pr__nfet_01v8_lvt L=0.15 W=8 nf=4 ad='int((nf+1)/2) * W/nf * 0.29' as='int((nf+2)/2) * W/nf * 0.29'
+ pd='2*int((nf+1)/2) * (W/nf + 0.29)' ps='2*int((nf+2)/2) * (W/nf + 0.29)' nrd='0.29 / W' nrs='0.29 / W' sa=0 sb=0 sd=0 mult=1
XM4 op inn in_stage_net1 VGND sky130_fd_pr__nfet_01v8_lvt L=0.15 W=8 nf=4 ad='int((nf+1)/2) * W/nf * 0.29' as='int((nf+2)/2) * W/nf * 0.29'
+ pd='2*int((nf+1)/2) * (W/nf + 0.29)' ps='2*int((nf+2)/2) * (W/nf + 0.29)' nrd='0.29 / W' nrs='0.29 / W' sa=0 sb=0 sd=0 mult=1
XM5 in_stage_net1 clk VGND VGND sky130_fd_pr__nfet_01v8 L=0.15 W=4 nf=8 ad='int((nf+1)/2) * W/nf * 0.29' as='int((nf+2)/2) * W/nf * 0.29'
+ pd='2*int((nf+1)/2) * (W/nf + 0.29)' ps='2*int((nf+2)/2) * (W/nf + 0.29)' nrd='0.29 / W' nrs='0.29 / W' sa=0 sb=0 sd=0 mult=1
XM6 in_stage_net2 bp VPWR VPWR sky130_fd_pr__pfet_01v8 L=0.15 W=4 nf=2 ad='int((nf+1)/2) * W/nf * 0.29' as='int((nf+2)/2) * W/nf * 0.29'
+ pd='2*int((nf+1)/2) * (W/nf + 0.29)' ps='2*int((nf+2)/2) * (W/nf + 0.29)' nrd='0.29 / W' nrs='0.29 / W' sa=0 sb=0 sd=0 mult=1
XM7 in_stage_net3 bn VPWR VPWR sky130_fd_pr__pfet_01v8 L=0.15 W=4 nf=2 ad='int((nf+1)/2) * W/nf * 0.29' as='int((nf+2)/2) * W/nf * 0.29'
+ pd='2*int((nf+1)/2) * (W/nf + 0.29)' ps='2*int((nf+2)/2) * (W/nf + 0.29)' nrd='0.29 / W' nrs='0.29 / W' sa=0 sb=0 sd=0 mult=1
XM8 bn op in_stage_net2 VPWR sky130_fd_pr__pfet_01v8 L=0.15 W=4 nf=2 ad='int((nf+1)/2) * W/nf * 0.29' as='int((nf+2)/2) * W/nf * 0.29'
+ pd='2*int((nf+1)/2) * (W/nf + 0.29)' ps='2*int((nf+2)/2) * (W/nf + 0.29)' nrd='0.29 / W' nrs='0.29 / W' sa=0 sb=0 sd=0 mult=1
XM9 bp on in_stage_net3 VPWR sky130_fd_pr__pfet_01v8 L=0.15 W=4 nf=2 ad='int((nf+1)/2) * W/nf * 0.29' as='int((nf+2)/2) * W/nf * 0.29'
+ pd='2*int((nf+1)/2) * (W/nf + 0.29)' ps='2*int((nf+2)/2) * (W/nf + 0.29)' nrd='0.29 / W' nrs='0.29 / W' sa=0 sb=0 sd=0 mult=1
XM10 bn bp VGND VGND sky130_fd_pr__nfet_01v8 L=0.15 W=2 nf=1 ad='int((nf+1)/2) * W/nf * 0.29' as='int((nf+2)/2) * W/nf * 0.29' pd='2*int((nf+1)/2) * (W/nf + 0.29)'
+ ps='2*int((nf+2)/2) * (W/nf + 0.29)' nrd='0.29 / W' nrs='0.29 / W' sa=0 sb=0 sd=0 mult=1
XM11 bn nclk VGND VGND sky130_fd_pr__nfet_01v8 L=0.15 W=2 nf=1 ad='int((nf+1)/2) * W/nf * 0.29' as='int((nf+2)/2) * W/nf * 0.29' pd='2*int((nf+1)/2) * (W/nf + 0.29)'
+ ps='2*int((nf+2)/2) * (W/nf + 0.29)' nrd='0.29 / W' nrs='0.29 / W' sa=0 sb=0 sd=0 mult=1
XM12 bp nclk VGND VGND sky130_fd_pr__nfet_01v8 L=0.15 W=2 nf=1 ad='int((nf+1)/2) * W/nf * 0.29' as='int((nf+2)/2) * W/nf * 0.29' pd='2*int((nf+1)/2) * (W/nf + 0.29)'
+ ps='2*int((nf+2)/2) * (W/nf + 0.29)' nrd='0.29 / W' nrs='0.29 / W' sa=0 sb=0 sd=0 mult=1
XM13 bp bn VGND VGND sky130_fd_pr__nfet_01v8 L=0.15 W=2 nf=1 ad='int((nf+1)/2) * W/nf * 0.29' as='int((nf+2)/2) * W/nf * 0.29' pd='2*int((nf+1)/2) * (W/nf + 0.29)'
+ ps='2*int((nf+2)/2) * (W/nf + 0.29)' nrd='0.29 / W' nrs='0.29 / W' sa=0 sb=0 sd=0 mult=1
XM2 op clk VPWR VPWR sky130_fd_pr__pfet_01v8 L=0.15 W=2 nf=4 ad='int((nf+1)/2) * W/nf * 0.29' as='int((nf+2)/2) * W/nf * 0.29' pd='2*int((nf+1)/2) * (W/nf + 0.29)'
+ ps='2*int((nf+2)/2) * (W/nf + 0.29)' nrd='0.29 / W' nrs='0.29 / W' sa=0 sb=0 sd=0 mult=1
XM1 on clk VPWR VPWR sky130_fd_pr__pfet_01v8 L=0.15 W=2 nf=4 ad='int((nf+1)/2) * W/nf * 0.29' as='int((nf+2)/2) * W/nf * 0.29' pd='2*int((nf+1)/2) * (W/nf + 0.29)'
+ ps='2*int((nf+2)/2) * (W/nf + 0.29)' nrd='0.29 / W' nrs='0.29 / W' sa=0 sb=0 sd=0 mult=1
x1 VPWR VGND bp outp adc_comp_buffer
x2 VPWR VGND bn outn adc_comp_buffer
x3 VGND VGND on VGND VGND adc_noise_decoup_cell2
x4 VGND VGND op VGND VGND adc_noise_decoup_cell2
XM4_DUMMY in_stage_net1 inn in_stage_net1 VGND sky130_fd_pr__nfet_01v8_lvt L=0.15 W=2 nf=1 ad='int((nf+1)/2) * W/nf * 0.29' as='int((nf+2)/2) * W/nf * 0.29'
+ pd='2*int((nf+1)/2) * (W/nf + 0.29)' ps='2*int((nf+2)/2) * (W/nf + 0.29)' nrd='0.29 / W' nrs='0.29 / W' sa=0 sb=0 sd=0 mult=1
XM3_DUMMY in_stage_net1 inp in_stage_net1 VGND sky130_fd_pr__nfet_01v8_lvt L=0.15 W=2 nf=1 ad='int((nf+1)/2) * W/nf * 0.29' as='int((nf+2)/2) * W/nf * 0.29'
+ pd='2*int((nf+1)/2) * (W/nf + 0.29)' ps='2*int((nf+2)/2) * (W/nf + 0.29)' nrd='0.29 / W' nrs='0.29 / W' sa=0 sb=0 sd=0 mult=1
XM5_DUMMY2 in_stage_net1 clk in_stage_net1 VGND sky130_fd_pr__nfet_01v8 L=0.15 W=0.5 nf=1 ad='int((nf+1)/2) * W/nf * 0.29' as='int((nf+2)/2) * W/nf * 0.29'
+ pd='2*int((nf+1)/2) * (W/nf + 0.29)' ps='2*int((nf+2)/2) * (W/nf + 0.29)' nrd='0.29 / W' nrs='0.29 / W' sa=0 sb=0 sd=0 mult=1
XM5_DUMMY1 in_stage_net1 clk in_stage_net1 VGND sky130_fd_pr__nfet_01v8 L=0.15 W=0.5 nf=1 ad='int((nf+1)/2) * W/nf * 0.29' as='int((nf+2)/2) * W/nf * 0.29'
+ pd='2*int((nf+1)/2) * (W/nf + 0.29)' ps='2*int((nf+2)/2) * (W/nf + 0.29)' nrd='0.29 / W' nrs='0.29 / W' sa=0 sb=0 sd=0 mult=1
XM2_DUMMY VPWR clk VPWR VPWR sky130_fd_pr__pfet_01v8 L=0.15 W=0.5 nf=1 ad='int((nf+1)/2) * W/nf * 0.29' as='int((nf+2)/2) * W/nf * 0.29'
+ pd='2*int((nf+1)/2) * (W/nf + 0.29)' ps='2*int((nf+2)/2) * (W/nf + 0.29)' nrd='0.29 / W' nrs='0.29 / W' sa=0 sb=0 sd=0 mult=1
XM1_DUMMY VPWR clk VPWR VPWR sky130_fd_pr__pfet_01v8 L=0.15 W=0.5 nf=1 ad='int((nf+1)/2) * W/nf * 0.29' as='int((nf+2)/2) * W/nf * 0.29'
+ pd='2*int((nf+1)/2) * (W/nf + 0.29)' ps='2*int((nf+2)/2) * (W/nf + 0.29)' nrd='0.29 / W' nrs='0.29 / W' sa=0 sb=0 sd=0 mult=1
XM8_DUMMY in_stage_net2 op in_stage_net2 VPWR sky130_fd_pr__pfet_01v8 L=0.15 W=2 nf=1 ad='int((nf+1)/2) * W/nf * 0.29' as='int((nf+2)/2) * W/nf * 0.29'
+ pd='2*int((nf+1)/2) * (W/nf + 0.29)' ps='2*int((nf+2)/2) * (W/nf + 0.29)' nrd='0.29 / W' nrs='0.29 / W' sa=0 sb=0 sd=0 mult=1
XM9_DUMMY in_stage_net3 on in_stage_net3 VPWR sky130_fd_pr__pfet_01v8 L=0.15 W=2 nf=1 ad='int((nf+1)/2) * W/nf * 0.29' as='int((nf+2)/2) * W/nf * 0.29'
+ pd='2*int((nf+1)/2) * (W/nf + 0.29)' ps='2*int((nf+2)/2) * (W/nf + 0.29)' nrd='0.29 / W' nrs='0.29 / W' sa=0 sb=0 sd=0 mult=1
XM6_DUMMY in_stage_net2 bp in_stage_net2 VPWR sky130_fd_pr__pfet_01v8 L=0.15 W=2 nf=1 ad='int((nf+1)/2) * W/nf * 0.29' as='int((nf+2)/2) * W/nf * 0.29'
+ pd='2*int((nf+1)/2) * (W/nf + 0.29)' ps='2*int((nf+2)/2) * (W/nf + 0.29)' nrd='0.29 / W' nrs='0.29 / W' sa=0 sb=0 sd=0 mult=1
XM7_DUMMY in_stage_net3 bn in_stage_net3 VPWR sky130_fd_pr__pfet_01v8 L=0.15 W=2 nf=1 ad='int((nf+1)/2) * W/nf * 0.29' as='int((nf+2)/2) * W/nf * 0.29'
+ pd='2*int((nf+1)/2) * (W/nf + 0.29)' ps='2*int((nf+2)/2) * (W/nf + 0.29)' nrd='0.29 / W' nrs='0.29 / W' sa=0 sb=0 sd=0 mult=1
XM12_DUMMY VGND VGND VGND VGND sky130_fd_pr__nfet_01v8 L=0.15 W=2 nf=1 ad='int((nf+1)/2) * W/nf * 0.29' as='int((nf+2)/2) * W/nf * 0.29'
+ pd='2*int((nf+1)/2) * (W/nf + 0.29)' ps='2*int((nf+2)/2) * (W/nf + 0.29)' nrd='0.29 / W' nrs='0.29 / W' sa=0 sb=0 sd=0 mult=1
XM11_DUMMY VGND VGND VGND VGND sky130_fd_pr__nfet_01v8 L=0.15 W=2 nf=1 ad='int((nf+1)/2) * W/nf * 0.29' as='int((nf+2)/2) * W/nf * 0.29'
+ pd='2*int((nf+1)/2) * (W/nf + 0.29)' ps='2*int((nf+2)/2) * (W/nf + 0.29)' nrd='0.29 / W' nrs='0.29 / W' sa=0 sb=0 sd=0 mult=1
.ends

* expanding   symbol:  adc_nor.sym # of pins=5
** sym_path: /home/agrancagnolo/Prueba_PI_Lore/SoC_for_CubeSat/xschem/adc_nor.sym
** sch_path: /home/agrancagnolo/Prueba_PI_Lore/SoC_for_CubeSat/xschem/adc_nor.sch
.subckt adc_nor b a VDD q VSS
*.iopin VDD
*.iopin VSS
*.ipin b
*.ipin a
*.opin q
XM5 q b VSS VSS sky130_fd_pr__nfet_01v8 L=0.15 W=0.42 nf=1 ad='int((nf+1)/2) * W/nf * 0.29' as='int((nf+2)/2) * W/nf * 0.29' pd='2*int((nf+1)/2) * (W/nf + 0.29)'
+ ps='2*int((nf+2)/2) * (W/nf + 0.29)' nrd='0.29 / W' nrs='0.29 / W' sa=0 sb=0 sd=0 mult=1
XM6 q a VSS VSS sky130_fd_pr__nfet_01v8 L=0.15 W=0.42 nf=1 ad='int((nf+1)/2) * W/nf * 0.29' as='int((nf+2)/2) * W/nf * 0.29' pd='2*int((nf+1)/2) * (W/nf + 0.29)'
+ ps='2*int((nf+2)/2) * (W/nf + 0.29)' nrd='0.29 / W' nrs='0.29 / W' sa=0 sb=0 sd=0 mult=1
XM1 q b net1 VDD sky130_fd_pr__pfet_01v8 L=0.15 W=0.8 nf=1 ad='int((nf+1)/2) * W/nf * 0.29' as='int((nf+2)/2) * W/nf * 0.29' pd='2*int((nf+1)/2) * (W/nf + 0.29)'
+ ps='2*int((nf+2)/2) * (W/nf + 0.29)' nrd='0.29 / W' nrs='0.29 / W' sa=0 sb=0 sd=0 mult=1
XM2 q a net2 VDD sky130_fd_pr__pfet_01v8 L=0.15 W=0.8 nf=1 ad='int((nf+1)/2) * W/nf * 0.29' as='int((nf+2)/2) * W/nf * 0.29' pd='2*int((nf+1)/2) * (W/nf + 0.29)'
+ ps='2*int((nf+2)/2) * (W/nf + 0.29)' nrd='0.29 / W' nrs='0.29 / W' sa=0 sb=0 sd=0 mult=1
XM3 net2 b VDD VDD sky130_fd_pr__pfet_01v8 L=0.15 W=0.8 nf=1 ad='int((nf+1)/2) * W/nf * 0.29' as='int((nf+2)/2) * W/nf * 0.29' pd='2*int((nf+1)/2) * (W/nf + 0.29)'
+ ps='2*int((nf+2)/2) * (W/nf + 0.29)' nrd='0.29 / W' nrs='0.29 / W' sa=0 sb=0 sd=0 mult=1
XM4 net1 a VDD VDD sky130_fd_pr__pfet_01v8 L=0.15 W=0.8 nf=1 ad='int((nf+1)/2) * W/nf * 0.29' as='int((nf+2)/2) * W/nf * 0.29' pd='2*int((nf+1)/2) * (W/nf + 0.29)'
+ ps='2*int((nf+2)/2) * (W/nf + 0.29)' nrd='0.29 / W' nrs='0.29 / W' sa=0 sb=0 sd=0 mult=1
.ends

* expanding   symbol:  adc_nor_latch.sym # of pins=6
** sym_path: /home/agrancagnolo/Prueba_PI_Lore/SoC_for_CubeSat/xschem/adc_nor_latch.sym
** sch_path: /home/agrancagnolo/Prueba_PI_Lore/SoC_for_CubeSat/xschem/adc_nor_latch.sch
.subckt adc_nor_latch s qn VDD q VSS r
*.iopin VDD
*.iopin VSS
*.ipin s
*.ipin r
*.opin q
*.opin qn
x1 q s VDD qn VSS adc_nor
x2 qn r VDD q VSS adc_nor
.ends

* expanding   symbol:  adc_array_circuit_8.sym # of pins=11
** sym_path: /home/agrancagnolo/Prueba_PI_Lore/SoC_for_CubeSat/xschem/adc_array_circuit_8.sym
** sch_path: /home/agrancagnolo/Prueba_PI_Lore/SoC_for_CubeSat/xschem/adc_array_circuit_8.sch
.subckt adc_array_circuit_8 VDD col_n Cbot row_n rowon_n sample_n vcom sample VSS rowoff_n col
*.ipin sample_n
*.ipin sample
*.iopin vcom
*.ipin col_n
*.ipin row_n
*.ipin rowon_n
*.iopin VDD
*.iopin VSS
*.iopin Cbot
*.ipin col
*.ipin rowoff_n
XM1 vcom sample Cbot VSS sky130_fd_pr__nfet_01v8 L=0.15 W=0.42 nf=1 ad='int((nf+1)/2) * W/nf * 0.29' as='int((nf+2)/2) * W/nf * 0.29'
+ pd='2*int((nf+1)/2) * (W/nf + 0.29)' ps='2*int((nf+2)/2) * (W/nf + 0.29)' nrd='0.29 / W' nrs='0.29 / W' sa=0 sb=0 sd=0 mult=1
XM3 vcom sample_n Cbot VDD sky130_fd_pr__pfet_01v8 L=0.15 W=0.8 nf=1 ad='int((nf+1)/2) * W/nf * 0.29' as='int((nf+2)/2) * W/nf * 0.29'
+ pd='2*int((nf+1)/2) * (W/nf + 0.29)' ps='2*int((nf+2)/2) * (W/nf + 0.29)' nrd='0.29 / W' nrs='0.29 / W' sa=0 sb=0 sd=0 mult=1
XM2 vdrv sample_n Cbot VSS sky130_fd_pr__nfet_01v8 L=0.15 W=0.42 nf=1 ad='int((nf+1)/2) * W/nf * 0.29' as='int((nf+2)/2) * W/nf * 0.29'
+ pd='2*int((nf+1)/2) * (W/nf + 0.29)' ps='2*int((nf+2)/2) * (W/nf + 0.29)' nrd='0.29 / W' nrs='0.29 / W' sa=0 sb=0 sd=0 mult=1
XM4 vdrv sample Cbot VDD sky130_fd_pr__pfet_01v8 L=0.15 W=0.8 nf=1 ad='int((nf+1)/2) * W/nf * 0.29' as='int((nf+2)/2) * W/nf * 0.29'
+ pd='2*int((nf+1)/2) * (W/nf + 0.29)' ps='2*int((nf+2)/2) * (W/nf + 0.29)' nrd='0.29 / W' nrs='0.29 / W' sa=0 sb=0 sd=0 mult=1
XM5 vint1 row_n vdrv VDD sky130_fd_pr__pfet_01v8 L=0.15 W=0.8 nf=1 ad='int((nf+1)/2) * W/nf * 0.29' as='int((nf+2)/2) * W/nf * 0.29'
+ pd='2*int((nf+1)/2) * (W/nf + 0.29)' ps='2*int((nf+2)/2) * (W/nf + 0.29)' nrd='0.29 / W' nrs='0.29 / W' sa=0 sb=0 sd=0 mult=1
XM6 VDD col_n vint1 VDD sky130_fd_pr__pfet_01v8 L=0.15 W=0.8 nf=1 ad='int((nf+1)/2) * W/nf * 0.29' as='int((nf+2)/2) * W/nf * 0.29'
+ pd='2*int((nf+1)/2) * (W/nf + 0.29)' ps='2*int((nf+2)/2) * (W/nf + 0.29)' nrd='0.29 / W' nrs='0.29 / W' sa=0 sb=0 sd=0 mult=1
XM7 VDD rowon_n vdrv VDD sky130_fd_pr__pfet_01v8 L=0.15 W=0.8 nf=1 ad='int((nf+1)/2) * W/nf * 0.29' as='int((nf+2)/2) * W/nf * 0.29'
+ pd='2*int((nf+1)/2) * (W/nf + 0.29)' ps='2*int((nf+2)/2) * (W/nf + 0.29)' nrd='0.29 / W' nrs='0.29 / W' sa=0 sb=0 sd=0 mult=1
XM8 vint2 rowon_n vdrv VSS sky130_fd_pr__nfet_01v8 L=0.15 W=0.42 nf=1 ad='int((nf+1)/2) * W/nf * 0.29' as='int((nf+2)/2) * W/nf * 0.29'
+ pd='2*int((nf+1)/2) * (W/nf + 0.29)' ps='2*int((nf+2)/2) * (W/nf + 0.29)' nrd='0.29 / W' nrs='0.29 / W' sa=0 sb=0 sd=0 mult=1
XM9 VSS col_n vint2 VSS sky130_fd_pr__nfet_01v8 L=0.15 W=0.42 nf=1 ad='int((nf+1)/2) * W/nf * 0.29' as='int((nf+2)/2) * W/nf * 0.29'
+ pd='2*int((nf+1)/2) * (W/nf + 0.29)' ps='2*int((nf+2)/2) * (W/nf + 0.29)' nrd='0.29 / W' nrs='0.29 / W' sa=0 sb=0 sd=0 mult=1
XM10 VSS row_n vint2 VSS sky130_fd_pr__nfet_01v8 L=0.15 W=0.42 nf=1 ad='int((nf+1)/2) * W/nf * 0.29' as='int((nf+2)/2) * W/nf * 0.29'
+ pd='2*int((nf+1)/2) * (W/nf + 0.29)' ps='2*int((nf+2)/2) * (W/nf + 0.29)' nrd='0.29 / W' nrs='0.29 / W' sa=0 sb=0 sd=0 mult=1
* noconn col
* noconn rowoff_n
.ends

* expanding   symbol:  adc_array_circuit_drv.sym # of pins=12
** sym_path: /home/agrancagnolo/Prueba_PI_Lore/SoC_for_CubeSat/xschem/adc_array_circuit_drv.sym
** sch_path: /home/agrancagnolo/Prueba_PI_Lore/SoC_for_CubeSat/xschem/adc_array_circuit_drv.sch
.subckt adc_array_circuit_drv VDD col_n row_n rowon_n sample_n_i vcom sample_i VSS sample_n_o sample_o rowoff_n col
*.ipin sample_n_i
*.ipin sample_i
*.iopin vcom
*.ipin row_n
*.ipin col_n
*.ipin rowon_n
*.iopin VDD
*.iopin VSS
*.opin sample_o
*.opin sample_n_o
*.ipin rowoff_n
*.ipin col
XM6 VDD sample_i net1 VDD sky130_fd_pr__pfet_01v8 L=0.15 W=1.2 nf=1 ad='int((nf+1)/2) * W/nf * 0.29' as='int((nf+2)/2) * W/nf * 0.29'
+ pd='2*int((nf+1)/2) * (W/nf + 0.29)' ps='2*int((nf+2)/2) * (W/nf + 0.29)' nrd='0.29 / W' nrs='0.29 / W' sa=0 sb=0 sd=0 mult=1
XM10 VSS sample_i net1 VSS sky130_fd_pr__nfet_01v8 L=0.15 W=0.6 nf=1 ad='int((nf+1)/2) * W/nf * 0.29' as='int((nf+2)/2) * W/nf * 0.29'
+ pd='2*int((nf+1)/2) * (W/nf + 0.29)' ps='2*int((nf+2)/2) * (W/nf + 0.29)' nrd='0.29 / W' nrs='0.29 / W' sa=0 sb=0 sd=0 mult=1
* noconn row_n
* noconn col_n
* noconn rowon_n
* noconn vcom
* noconn rowoff_n
* noconn col
XM1 VDD net1 sample_o VDD sky130_fd_pr__pfet_01v8 L=0.15 W=1.2 nf=1 ad='int((nf+1)/2) * W/nf * 0.29' as='int((nf+2)/2) * W/nf * 0.29'
+ pd='2*int((nf+1)/2) * (W/nf + 0.29)' ps='2*int((nf+2)/2) * (W/nf + 0.29)' nrd='0.29 / W' nrs='0.29 / W' sa=0 sb=0 sd=0 mult=1
XM2 VSS net1 sample_o VSS sky130_fd_pr__nfet_01v8 L=0.15 W=0.6 nf=1 ad='int((nf+1)/2) * W/nf * 0.29' as='int((nf+2)/2) * W/nf * 0.29'
+ pd='2*int((nf+1)/2) * (W/nf + 0.29)' ps='2*int((nf+2)/2) * (W/nf + 0.29)' nrd='0.29 / W' nrs='0.29 / W' sa=0 sb=0 sd=0 mult=1
* noconn sample_n_i
XM3 sample_i VSS net2 VDD sky130_fd_pr__pfet_01v8 L=0.15 W=1.2 nf=1 ad='int((nf+1)/2) * W/nf * 0.29' as='int((nf+2)/2) * W/nf * 0.29'
+ pd='2*int((nf+1)/2) * (W/nf + 0.29)' ps='2*int((nf+2)/2) * (W/nf + 0.29)' nrd='0.29 / W' nrs='0.29 / W' sa=0 sb=0 sd=0 mult=1
XM4 net2 VDD sample_i VSS sky130_fd_pr__nfet_01v8 L=0.15 W=0.6 nf=1 ad='int((nf+1)/2) * W/nf * 0.29' as='int((nf+2)/2) * W/nf * 0.29'
+ pd='2*int((nf+1)/2) * (W/nf + 0.29)' ps='2*int((nf+2)/2) * (W/nf + 0.29)' nrd='0.29 / W' nrs='0.29 / W' sa=0 sb=0 sd=0 mult=1
XM5 VDD net2 sample_n_o VDD sky130_fd_pr__pfet_01v8 L=0.15 W=1.2 nf=1 ad='int((nf+1)/2) * W/nf * 0.29' as='int((nf+2)/2) * W/nf * 0.29'
+ pd='2*int((nf+1)/2) * (W/nf + 0.29)' ps='2*int((nf+2)/2) * (W/nf + 0.29)' nrd='0.29 / W' nrs='0.29 / W' sa=0 sb=0 sd=0 mult=1
XM7 VSS net2 sample_n_o VSS sky130_fd_pr__nfet_01v8 L=0.15 W=0.6 nf=1 ad='int((nf+1)/2) * W/nf * 0.29' as='int((nf+2)/2) * W/nf * 0.29'
+ pd='2*int((nf+1)/2) * (W/nf + 0.29)' ps='2*int((nf+2)/2) * (W/nf + 0.29)' nrd='0.29 / W' nrs='0.29 / W' sa=0 sb=0 sd=0 mult=1
.ends

* expanding   symbol:  adc_array_circuit_4.sym # of pins=12
** sym_path: /home/agrancagnolo/Prueba_PI_Lore/SoC_for_CubeSat/xschem/adc_array_circuit_4.sym
** sch_path: /home/agrancagnolo/Prueba_PI_Lore/SoC_for_CubeSat/xschem/adc_array_circuit_4.sch
.subckt adc_array_circuit_4 VDD col_n Cbot row_n rowon_n sample_n vcom sample VSS en_n rowoff_n col
*.ipin sample_n
*.ipin sample
*.iopin vcom
*.ipin rowoff_n
*.ipin row_n
*.ipin rowon_n
*.iopin VDD
*.iopin VSS
*.iopin Cbot
*.ipin en_n
*.ipin col_n
*.ipin col
XM1 vcom sample Cbot VSS sky130_fd_pr__nfet_01v8 L=0.15 W=0.42 nf=1 ad='int((nf+1)/2) * W/nf * 0.29' as='int((nf+2)/2) * W/nf * 0.29'
+ pd='2*int((nf+1)/2) * (W/nf + 0.29)' ps='2*int((nf+2)/2) * (W/nf + 0.29)' nrd='0.29 / W' nrs='0.29 / W' sa=0 sb=0 sd=0 mult=1
XM3 vcom sample_n Cbot VDD sky130_fd_pr__pfet_01v8 L=0.15 W=0.8 nf=1 ad='int((nf+1)/2) * W/nf * 0.29' as='int((nf+2)/2) * W/nf * 0.29'
+ pd='2*int((nf+1)/2) * (W/nf + 0.29)' ps='2*int((nf+2)/2) * (W/nf + 0.29)' nrd='0.29 / W' nrs='0.29 / W' sa=0 sb=0 sd=0 mult=1
XM2 vdrv sample_n Cbot VSS sky130_fd_pr__nfet_01v8 L=0.15 W=0.42 nf=1 ad='int((nf+1)/2) * W/nf * 0.29' as='int((nf+2)/2) * W/nf * 0.29'
+ pd='2*int((nf+1)/2) * (W/nf + 0.29)' ps='2*int((nf+2)/2) * (W/nf + 0.29)' nrd='0.29 / W' nrs='0.29 / W' sa=0 sb=0 sd=0 mult=1
XM4 vdrv sample Cbot VDD sky130_fd_pr__pfet_01v8 L=0.15 W=0.8 nf=1 ad='int((nf+1)/2) * W/nf * 0.29' as='int((nf+2)/2) * W/nf * 0.29'
+ pd='2*int((nf+1)/2) * (W/nf + 0.29)' ps='2*int((nf+2)/2) * (W/nf + 0.29)' nrd='0.29 / W' nrs='0.29 / W' sa=0 sb=0 sd=0 mult=1
XM5 vint1 en_n vdrv VDD sky130_fd_pr__pfet_01v8 L=0.15 W=0.8 nf=1 ad='int((nf+1)/2) * W/nf * 0.29' as='int((nf+2)/2) * W/nf * 0.29'
+ pd='2*int((nf+1)/2) * (W/nf + 0.29)' ps='2*int((nf+2)/2) * (W/nf + 0.29)' nrd='0.29 / W' nrs='0.29 / W' sa=0 sb=0 sd=0 mult=1
XM6 VDD en_n vint1 VDD sky130_fd_pr__pfet_01v8 L=0.15 W=0.8 nf=1 ad='int((nf+1)/2) * W/nf * 0.29' as='int((nf+2)/2) * W/nf * 0.29'
+ pd='2*int((nf+1)/2) * (W/nf + 0.29)' ps='2*int((nf+2)/2) * (W/nf + 0.29)' nrd='0.29 / W' nrs='0.29 / W' sa=0 sb=0 sd=0 mult=1
XM7 VDD en_n vdrv VDD sky130_fd_pr__pfet_01v8 L=0.15 W=0.8 nf=1 ad='int((nf+1)/2) * W/nf * 0.29' as='int((nf+2)/2) * W/nf * 0.29' pd='2*int((nf+1)/2) * (W/nf + 0.29)'
+ ps='2*int((nf+2)/2) * (W/nf + 0.29)' nrd='0.29 / W' nrs='0.29 / W' sa=0 sb=0 sd=0 mult=1
XM8 vint2 en_n vdrv VSS sky130_fd_pr__nfet_01v8 L=0.15 W=0.42 nf=1 ad='int((nf+1)/2) * W/nf * 0.29' as='int((nf+2)/2) * W/nf * 0.29'
+ pd='2*int((nf+1)/2) * (W/nf + 0.29)' ps='2*int((nf+2)/2) * (W/nf + 0.29)' nrd='0.29 / W' nrs='0.29 / W' sa=0 sb=0 sd=0 mult=1
XM9 VSS en_n vint2 VSS sky130_fd_pr__nfet_01v8 L=0.15 W=0.42 nf=1 ad='int((nf+1)/2) * W/nf * 0.29' as='int((nf+2)/2) * W/nf * 0.29'
+ pd='2*int((nf+1)/2) * (W/nf + 0.29)' ps='2*int((nf+2)/2) * (W/nf + 0.29)' nrd='0.29 / W' nrs='0.29 / W' sa=0 sb=0 sd=0 mult=1
XM10 VSS en_n vint2 VSS sky130_fd_pr__nfet_01v8 L=0.15 W=0.42 nf=1 ad='int((nf+1)/2) * W/nf * 0.29' as='int((nf+2)/2) * W/nf * 0.29'
+ pd='2*int((nf+1)/2) * (W/nf + 0.29)' ps='2*int((nf+2)/2) * (W/nf + 0.29)' nrd='0.29 / W' nrs='0.29 / W' sa=0 sb=0 sd=0 mult=1
* noconn rowoff_n
* noconn row_n
* noconn rowon_n
* noconn col_n
* noconn col
.ends

* expanding   symbol:  adc_array_circuit_2.sym # of pins=12
** sym_path: /home/agrancagnolo/Prueba_PI_Lore/SoC_for_CubeSat/xschem/adc_array_circuit_2.sym
** sch_path: /home/agrancagnolo/Prueba_PI_Lore/SoC_for_CubeSat/xschem/adc_array_circuit_2.sch
.subckt adc_array_circuit_2 VDD col_n Cbot row_n rowon_n sample_n vcom sample VSS en_n rowoff_n col
*.ipin sample_n
*.ipin sample
*.iopin vcom
*.ipin rowoff_n
*.ipin row_n
*.ipin rowon_n
*.iopin VDD
*.iopin VSS
*.iopin Cbot
*.ipin en_n
*.ipin col
*.ipin col_n
XM1 vcom sample Cbot VSS sky130_fd_pr__nfet_01v8 L=0.15 W=0.42 nf=1 ad='int((nf+1)/2) * W/nf * 0.29' as='int((nf+2)/2) * W/nf * 0.29'
+ pd='2*int((nf+1)/2) * (W/nf + 0.29)' ps='2*int((nf+2)/2) * (W/nf + 0.29)' nrd='0.29 / W' nrs='0.29 / W' sa=0 sb=0 sd=0 mult=1
XM3 vcom sample_n Cbot VDD sky130_fd_pr__pfet_01v8 L=0.15 W=0.8 nf=1 ad='int((nf+1)/2) * W/nf * 0.29' as='int((nf+2)/2) * W/nf * 0.29'
+ pd='2*int((nf+1)/2) * (W/nf + 0.29)' ps='2*int((nf+2)/2) * (W/nf + 0.29)' nrd='0.29 / W' nrs='0.29 / W' sa=0 sb=0 sd=0 mult=1
XM2 vdrv sample_n Cbot VSS sky130_fd_pr__nfet_01v8 L=0.15 W=0.42 nf=1 ad='int((nf+1)/2) * W/nf * 0.29' as='int((nf+2)/2) * W/nf * 0.29'
+ pd='2*int((nf+1)/2) * (W/nf + 0.29)' ps='2*int((nf+2)/2) * (W/nf + 0.29)' nrd='0.29 / W' nrs='0.29 / W' sa=0 sb=0 sd=0 mult=1
XM4 vdrv sample Cbot VDD sky130_fd_pr__pfet_01v8 L=0.15 W=0.8 nf=1 ad='int((nf+1)/2) * W/nf * 0.29' as='int((nf+2)/2) * W/nf * 0.29'
+ pd='2*int((nf+1)/2) * (W/nf + 0.29)' ps='2*int((nf+2)/2) * (W/nf + 0.29)' nrd='0.29 / W' nrs='0.29 / W' sa=0 sb=0 sd=0 mult=1
XM5 vint1 en_n vdrv VDD sky130_fd_pr__pfet_01v8 L=0.15 W=0.8 nf=1 ad='int((nf+1)/2) * W/nf * 0.29' as='int((nf+2)/2) * W/nf * 0.29'
+ pd='2*int((nf+1)/2) * (W/nf + 0.29)' ps='2*int((nf+2)/2) * (W/nf + 0.29)' nrd='0.29 / W' nrs='0.29 / W' sa=0 sb=0 sd=0 mult=1
XM6 VDD en_n vint1 VDD sky130_fd_pr__pfet_01v8 L=0.15 W=0.8 nf=1 ad='int((nf+1)/2) * W/nf * 0.29' as='int((nf+2)/2) * W/nf * 0.29'
+ pd='2*int((nf+1)/2) * (W/nf + 0.29)' ps='2*int((nf+2)/2) * (W/nf + 0.29)' nrd='0.29 / W' nrs='0.29 / W' sa=0 sb=0 sd=0 mult=1
XM7 VDD en_n vdrv VDD sky130_fd_pr__pfet_01v8 L=0.15 W=0.8 nf=1 ad='int((nf+1)/2) * W/nf * 0.29' as='int((nf+2)/2) * W/nf * 0.29' pd='2*int((nf+1)/2) * (W/nf + 0.29)'
+ ps='2*int((nf+2)/2) * (W/nf + 0.29)' nrd='0.29 / W' nrs='0.29 / W' sa=0 sb=0 sd=0 mult=1
XM8 vint2 en_n vdrv VSS sky130_fd_pr__nfet_01v8 L=0.15 W=0.42 nf=1 ad='int((nf+1)/2) * W/nf * 0.29' as='int((nf+2)/2) * W/nf * 0.29'
+ pd='2*int((nf+1)/2) * (W/nf + 0.29)' ps='2*int((nf+2)/2) * (W/nf + 0.29)' nrd='0.29 / W' nrs='0.29 / W' sa=0 sb=0 sd=0 mult=1
XM9 VSS en_n vint2 VSS sky130_fd_pr__nfet_01v8 L=0.15 W=0.42 nf=1 ad='int((nf+1)/2) * W/nf * 0.29' as='int((nf+2)/2) * W/nf * 0.29'
+ pd='2*int((nf+1)/2) * (W/nf + 0.29)' ps='2*int((nf+2)/2) * (W/nf + 0.29)' nrd='0.29 / W' nrs='0.29 / W' sa=0 sb=0 sd=0 mult=1
XM10 VSS en_n vint2 VSS sky130_fd_pr__nfet_01v8 L=0.15 W=0.42 nf=1 ad='int((nf+1)/2) * W/nf * 0.29' as='int((nf+2)/2) * W/nf * 0.29'
+ pd='2*int((nf+1)/2) * (W/nf + 0.29)' ps='2*int((nf+2)/2) * (W/nf + 0.29)' nrd='0.29 / W' nrs='0.29 / W' sa=0 sb=0 sd=0 mult=1
* noconn rowoff_n
* noconn row_n
* noconn rowon_n
* noconn col
* noconn col_n
.ends

* expanding   symbol:  adc_array_circuit_1.sym # of pins=12
** sym_path: /home/agrancagnolo/Prueba_PI_Lore/SoC_for_CubeSat/xschem/adc_array_circuit_1.sym
** sch_path: /home/agrancagnolo/Prueba_PI_Lore/SoC_for_CubeSat/xschem/adc_array_circuit_1.sch
.subckt adc_array_circuit_1 VDD col_n Cbot row_n rowon_n sample_n vcom sample VSS en_n rowoff_n col
*.ipin sample_n
*.ipin sample
*.iopin vcom
*.ipin row_n
*.ipin col_n
*.ipin rowon_n
*.iopin VDD
*.iopin VSS
*.iopin Cbot
*.ipin en_n
*.ipin rowoff_n
*.ipin col
XM1 vcom sample Cbot VSS sky130_fd_pr__nfet_01v8 L=0.15 W=0.42 nf=1 ad='int((nf+1)/2) * W/nf * 0.29' as='int((nf+2)/2) * W/nf * 0.29'
+ pd='2*int((nf+1)/2) * (W/nf + 0.29)' ps='2*int((nf+2)/2) * (W/nf + 0.29)' nrd='0.29 / W' nrs='0.29 / W' sa=0 sb=0 sd=0 mult=1
XM3 vcom sample_n Cbot VDD sky130_fd_pr__pfet_01v8 L=0.15 W=0.8 nf=1 ad='int((nf+1)/2) * W/nf * 0.29' as='int((nf+2)/2) * W/nf * 0.29'
+ pd='2*int((nf+1)/2) * (W/nf + 0.29)' ps='2*int((nf+2)/2) * (W/nf + 0.29)' nrd='0.29 / W' nrs='0.29 / W' sa=0 sb=0 sd=0 mult=1
XM2 vdrv sample_n Cbot VSS sky130_fd_pr__nfet_01v8 L=0.15 W=0.42 nf=1 ad='int((nf+1)/2) * W/nf * 0.29' as='int((nf+2)/2) * W/nf * 0.29'
+ pd='2*int((nf+1)/2) * (W/nf + 0.29)' ps='2*int((nf+2)/2) * (W/nf + 0.29)' nrd='0.29 / W' nrs='0.29 / W' sa=0 sb=0 sd=0 mult=1
XM4 vdrv sample Cbot VDD sky130_fd_pr__pfet_01v8 L=0.15 W=0.8 nf=1 ad='int((nf+1)/2) * W/nf * 0.29' as='int((nf+2)/2) * W/nf * 0.29'
+ pd='2*int((nf+1)/2) * (W/nf + 0.29)' ps='2*int((nf+2)/2) * (W/nf + 0.29)' nrd='0.29 / W' nrs='0.29 / W' sa=0 sb=0 sd=0 mult=1
XM5 vint1 en_n vdrv VDD sky130_fd_pr__pfet_01v8 L=0.15 W=0.8 nf=1 ad='int((nf+1)/2) * W/nf * 0.29' as='int((nf+2)/2) * W/nf * 0.29'
+ pd='2*int((nf+1)/2) * (W/nf + 0.29)' ps='2*int((nf+2)/2) * (W/nf + 0.29)' nrd='0.29 / W' nrs='0.29 / W' sa=0 sb=0 sd=0 mult=1
XM6 VDD en_n vint1 VDD sky130_fd_pr__pfet_01v8 L=0.15 W=0.8 nf=1 ad='int((nf+1)/2) * W/nf * 0.29' as='int((nf+2)/2) * W/nf * 0.29'
+ pd='2*int((nf+1)/2) * (W/nf + 0.29)' ps='2*int((nf+2)/2) * (W/nf + 0.29)' nrd='0.29 / W' nrs='0.29 / W' sa=0 sb=0 sd=0 mult=1
XM7 VDD en_n vdrv VDD sky130_fd_pr__pfet_01v8 L=0.15 W=0.8 nf=1 ad='int((nf+1)/2) * W/nf * 0.29' as='int((nf+2)/2) * W/nf * 0.29' pd='2*int((nf+1)/2) * (W/nf + 0.29)'
+ ps='2*int((nf+2)/2) * (W/nf + 0.29)' nrd='0.29 / W' nrs='0.29 / W' sa=0 sb=0 sd=0 mult=1
XM8 vint2 en_n vdrv VSS sky130_fd_pr__nfet_01v8 L=0.15 W=0.42 nf=1 ad='int((nf+1)/2) * W/nf * 0.29' as='int((nf+2)/2) * W/nf * 0.29'
+ pd='2*int((nf+1)/2) * (W/nf + 0.29)' ps='2*int((nf+2)/2) * (W/nf + 0.29)' nrd='0.29 / W' nrs='0.29 / W' sa=0 sb=0 sd=0 mult=1
XM9 VSS en_n vint2 VSS sky130_fd_pr__nfet_01v8 L=0.15 W=0.42 nf=1 ad='int((nf+1)/2) * W/nf * 0.29' as='int((nf+2)/2) * W/nf * 0.29'
+ pd='2*int((nf+1)/2) * (W/nf + 0.29)' ps='2*int((nf+2)/2) * (W/nf + 0.29)' nrd='0.29 / W' nrs='0.29 / W' sa=0 sb=0 sd=0 mult=1
XM10 VSS en_n vint2 VSS sky130_fd_pr__nfet_01v8 L=0.15 W=0.42 nf=1 ad='int((nf+1)/2) * W/nf * 0.29' as='int((nf+2)/2) * W/nf * 0.29'
+ pd='2*int((nf+1)/2) * (W/nf + 0.29)' ps='2*int((nf+2)/2) * (W/nf + 0.29)' nrd='0.29 / W' nrs='0.29 / W' sa=0 sb=0 sd=0 mult=1
* noconn row_n
* noconn col_n
* noconn rowon_n
* noconn rowoff_n
* noconn col
.ends

* expanding   symbol:  adc_array_circuit_gate.sym # of pins=14
** sym_path: /home/agrancagnolo/Prueba_PI_Lore/SoC_for_CubeSat/xschem/adc_array_circuit_gate.sym
** sch_path: /home/agrancagnolo/Prueba_PI_Lore/SoC_for_CubeSat/xschem/adc_array_circuit_gate.sch
.subckt adc_array_circuit_gate VDD col_n row_n rowon_n sample_n vcom sample VSS out in sw_n sw rowoff_n col
*.ipin sw
*.ipin sw_n
*.iopin vcom
*.ipin row_n
*.ipin col_n
*.ipin rowon_n
*.iopin VDD
*.iopin VSS
*.ipin sample
*.ipin sample_n
*.iopin in
*.iopin out
*.ipin col
*.ipin rowoff_n
* noconn row_n
* noconn col_n
* noconn rowon_n
* noconn vcom
* noconn sample
* noconn sample_n
X1 sw_n in sw out VDD VSS adc_gate_switch
* noconn col
* noconn rowoff_n
.ends

* expanding   symbol:  adc_comp_buffer.sym # of pins=4
** sym_path: /home/agrancagnolo/Prueba_PI_Lore/SoC_for_CubeSat/xschem/adc_comp_buffer.sym
** sch_path: /home/agrancagnolo/Prueba_PI_Lore/SoC_for_CubeSat/xschem/adc_comp_buffer.sch
.subckt adc_comp_buffer VDD VSS in out
*.iopin VDD
*.iopin VSS
*.ipin in
*.opin out
XM5 buf_mid in VSS VSS sky130_fd_pr__nfet_01v8 L=0.15 W=0.5 nf=1 ad='int((nf+1)/2) * W/nf * 0.29' as='int((nf+2)/2) * W/nf * 0.29'
+ pd='2*int((nf+1)/2) * (W/nf + 0.29)' ps='2*int((nf+2)/2) * (W/nf + 0.29)' nrd='0.29 / W' nrs='0.29 / W' sa=0 sb=0 sd=0 mult=1
XM1 buf_mid in VDD VDD sky130_fd_pr__pfet_01v8 L=0.15 W=1 nf=1 ad='int((nf+1)/2) * W/nf * 0.29' as='int((nf+2)/2) * W/nf * 0.29' pd='2*int((nf+1)/2) * (W/nf + 0.29)'
+ ps='2*int((nf+2)/2) * (W/nf + 0.29)' nrd='0.29 / W' nrs='0.29 / W' sa=0 sb=0 sd=0 mult=1
XM2 out buf_mid VDD VDD sky130_fd_pr__pfet_01v8 L=0.15 W=2 nf=2 ad='int((nf+1)/2) * W/nf * 0.29' as='int((nf+2)/2) * W/nf * 0.29' pd='2*int((nf+1)/2) * (W/nf + 0.29)'
+ ps='2*int((nf+2)/2) * (W/nf + 0.29)' nrd='0.29 / W' nrs='0.29 / W' sa=0 sb=0 sd=0 mult=1
XM6 out buf_mid VSS VSS sky130_fd_pr__nfet_01v8 L=0.15 W=1 nf=2 ad='int((nf+1)/2) * W/nf * 0.29' as='int((nf+2)/2) * W/nf * 0.29' pd='2*int((nf+1)/2) * (W/nf + 0.29)'
+ ps='2*int((nf+2)/2) * (W/nf + 0.29)' nrd='0.29 / W' nrs='0.29 / W' sa=0 sb=0 sd=0 mult=1
.ends

* expanding   symbol:  adc_noise_decoup_cell2.sym # of pins=5
** sym_path: /home/agrancagnolo/Prueba_PI_Lore/SoC_for_CubeSat/xschem/adc_noise_decoup_cell2.sym
** sch_path: /home/agrancagnolo/Prueba_PI_Lore/SoC_for_CubeSat/xschem/adc_noise_decoup_cell2.sch
.subckt adc_noise_decoup_cell2 mimcap_top mimcap_bot nmoscap_top nmoscap_bot pwell
*.iopin nmoscap_top
*.iopin mimcap_top
*.iopin mimcap_bot
*.iopin nmoscap_bot
*.iopin pwell
XC1 mimcap_top mimcap_bot sky130_fd_pr__cap_mim_m3_1 W=18.9 L=5.1 MF=1
XC2 nmoscap_top nmoscap_bot pwell sky130_fd_pr__cap_var_lvt W=18.4 L=3.9 VM=1
.ends

* expanding   symbol:  adc_gate_switch.sym # of pins=6
** sym_path: /home/agrancagnolo/Prueba_PI_Lore/SoC_for_CubeSat/xschem/adc_gate_switch.sym
** sch_path: /home/agrancagnolo/Prueba_PI_Lore/SoC_for_CubeSat/xschem/adc_gate_switch.sch
.subckt adc_gate_switch sw_n a sw b VDD VSS
*.iopin VSS
*.iopin VDD
*.ipin sw_n
*.ipin sw
*.iopin a
*.iopin b
XM1 a sw_n b VDD sky130_fd_pr__pfet_01v8 L=0.22 W=7.6 nf=4 ad='int((nf+1)/2) * W/nf * 0.29' as='int((nf+2)/2) * W/nf * 0.29' pd='2*int((nf+1)/2) * (W/nf + 0.29)'
+ ps='2*int((nf+2)/2) * (W/nf + 0.29)' nrd='0.29 / W' nrs='0.29 / W' sa=0 sb=0 sd=0 mult=1
XM3 a sw b VSS sky130_fd_pr__nfet_01v8 L=0.22 W=7.6 nf=4 ad='int((nf+1)/2) * W/nf * 0.29' as='int((nf+2)/2) * W/nf * 0.29' pd='2*int((nf+1)/2) * (W/nf + 0.29)'
+ ps='2*int((nf+2)/2) * (W/nf + 0.29)' nrd='0.29 / W' nrs='0.29 / W' sa=0 sb=0 sd=0 mult=1
XM2 b sw b VDD sky130_fd_pr__pfet_01v8 L=0.22 W=3.8 nf=2 ad='int((nf+1)/2) * W/nf * 0.29' as='int((nf+2)/2) * W/nf * 0.29' pd='2*int((nf+1)/2) * (W/nf + 0.29)'
+ ps='2*int((nf+2)/2) * (W/nf + 0.29)' nrd='0.29 / W' nrs='0.29 / W' sa=0 sb=0 sd=0 mult=1
XM4 b sw_n b VSS sky130_fd_pr__nfet_01v8 L=0.22 W=3.8 nf=2 ad='int((nf+1)/2) * W/nf * 0.29' as='int((nf+2)/2) * W/nf * 0.29' pd='2*int((nf+1)/2) * (W/nf + 0.29)'
+ ps='2*int((nf+2)/2) * (W/nf + 0.29)' nrd='0.29 / W' nrs='0.29 / W' sa=0 sb=0 sd=0 mult=1
.ends

.GLOBAL VDD
.GLOBAL GND
.end
